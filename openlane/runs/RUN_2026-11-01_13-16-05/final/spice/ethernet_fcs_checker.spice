* NGSPICE file created from ethernet_fcs_checker.ext - technology: sky130A

* Black-box entry subcircuit for sky130_fd_sc_hd__decap_3 abstract view
.subckt sky130_fd_sc_hd__decap_3 VGND VNB VPB VPWR
.ends

* Black-box entry subcircuit for sky130_ef_sc_hd__decap_12 abstract view
.subckt sky130_ef_sc_hd__decap_12 VPWR VGND VPB VNB
.ends

* Black-box entry subcircuit for sky130_fd_sc_hd__decap_6 abstract view
.subckt sky130_fd_sc_hd__decap_6 VGND VNB VPB VPWR
.ends

* Black-box entry subcircuit for sky130_fd_sc_hd__nand2_1 abstract view
.subckt sky130_fd_sc_hd__nand2_1 A B VGND VNB VPB VPWR Y
.ends

* Black-box entry subcircuit for sky130_fd_sc_hd__decap_8 abstract view
.subckt sky130_fd_sc_hd__decap_8 VGND VNB VPB VPWR
.ends

* Black-box entry subcircuit for sky130_fd_sc_hd__o21bai_1 abstract view
.subckt sky130_fd_sc_hd__o21bai_1 A1 A2 B1_N VGND VNB VPB VPWR Y
.ends

* Black-box entry subcircuit for sky130_fd_sc_hd__tapvpwrvgnd_1 abstract view
.subckt sky130_fd_sc_hd__tapvpwrvgnd_1 VGND VPWR
.ends

* Black-box entry subcircuit for sky130_fd_sc_hd__decap_4 abstract view
.subckt sky130_fd_sc_hd__decap_4 VGND VNB VPB VPWR
.ends

* Black-box entry subcircuit for sky130_fd_sc_hd__fill_1 abstract view
.subckt sky130_fd_sc_hd__fill_1 VGND VNB VPB VPWR
.ends

* Black-box entry subcircuit for sky130_fd_sc_hd__dfstp_1 abstract view
.subckt sky130_fd_sc_hd__dfstp_1 CLK D SET_B VGND VNB VPB VPWR Q
.ends

* Black-box entry subcircuit for sky130_fd_sc_hd__fill_2 abstract view
.subckt sky130_fd_sc_hd__fill_2 VGND VNB VPB VPWR
.ends

* Black-box entry subcircuit for sky130_fd_sc_hd__mux2_1 abstract view
.subckt sky130_fd_sc_hd__mux2_1 A0 A1 S VGND VNB VPB VPWR X
.ends

* Black-box entry subcircuit for sky130_fd_sc_hd__dfrtp_1 abstract view
.subckt sky130_fd_sc_hd__dfrtp_1 CLK D RESET_B VGND VNB VPB VPWR Q
.ends

* Black-box entry subcircuit for sky130_fd_sc_hd__nor2_1 abstract view
.subckt sky130_fd_sc_hd__nor2_1 A B VGND VNB VPB VPWR Y
.ends

* Black-box entry subcircuit for sky130_fd_sc_hd__inv_2 abstract view
.subckt sky130_fd_sc_hd__inv_2 A VGND VNB VPB VPWR Y
.ends

* Black-box entry subcircuit for sky130_fd_sc_hd__xnor2_1 abstract view
.subckt sky130_fd_sc_hd__xnor2_1 A B VGND VNB VPB VPWR Y
.ends

* Black-box entry subcircuit for sky130_fd_sc_hd__a21oi_1 abstract view
.subckt sky130_fd_sc_hd__a21oi_1 A1 A2 B1 VGND VNB VPB VPWR Y
.ends

* Black-box entry subcircuit for sky130_fd_sc_hd__buf_2 abstract view
.subckt sky130_fd_sc_hd__buf_2 A VGND VNB VPB VPWR X
.ends

* Black-box entry subcircuit for sky130_fd_sc_hd__o21a_1 abstract view
.subckt sky130_fd_sc_hd__o21a_1 A1 A2 B1 VGND VNB VPB VPWR X
.ends

* Black-box entry subcircuit for sky130_fd_sc_hd__o21ai_1 abstract view
.subckt sky130_fd_sc_hd__o21ai_1 A1 A2 B1 VGND VNB VPB VPWR Y
.ends

* Black-box entry subcircuit for sky130_fd_sc_hd__or3b_1 abstract view
.subckt sky130_fd_sc_hd__or3b_1 A B C_N VGND VNB VPB VPWR X
.ends

* Black-box entry subcircuit for sky130_fd_sc_hd__or2_1 abstract view
.subckt sky130_fd_sc_hd__or2_1 A B VGND VNB VPB VPWR X
.ends

* Black-box entry subcircuit for sky130_fd_sc_hd__clkbuf_16 abstract view
.subckt sky130_fd_sc_hd__clkbuf_16 A VGND VNB VPB VPWR X
.ends

* Black-box entry subcircuit for sky130_fd_sc_hd__xor2_2 abstract view
.subckt sky130_fd_sc_hd__xor2_2 A B VGND VNB VPB VPWR X
.ends

* Black-box entry subcircuit for sky130_fd_sc_hd__dlygate4sd3_1 abstract view
.subckt sky130_fd_sc_hd__dlygate4sd3_1 A VGND VNB VPB VPWR X
.ends

* Black-box entry subcircuit for sky130_fd_sc_hd__o31a_1 abstract view
.subckt sky130_fd_sc_hd__o31a_1 A1 A2 A3 B1 VGND VNB VPB VPWR X
.ends

* Black-box entry subcircuit for sky130_fd_sc_hd__and3_1 abstract view
.subckt sky130_fd_sc_hd__and3_1 A B C VGND VNB VPB VPWR X
.ends

* Black-box entry subcircuit for sky130_fd_sc_hd__o21ba_1 abstract view
.subckt sky130_fd_sc_hd__o21ba_1 A1 A2 B1_N VGND VNB VPB VPWR X
.ends

* Black-box entry subcircuit for sky130_fd_sc_hd__a21o_1 abstract view
.subckt sky130_fd_sc_hd__a21o_1 A1 A2 B1 VGND VNB VPB VPWR X
.ends

* Black-box entry subcircuit for sky130_fd_sc_hd__or3_1 abstract view
.subckt sky130_fd_sc_hd__or3_1 A B C VGND VNB VPB VPWR X
.ends

* Black-box entry subcircuit for sky130_fd_sc_hd__and4_1 abstract view
.subckt sky130_fd_sc_hd__and4_1 A B C D VGND VNB VPB VPWR X
.ends

* Black-box entry subcircuit for sky130_fd_sc_hd__a31o_1 abstract view
.subckt sky130_fd_sc_hd__a31o_1 A1 A2 A3 B1 VGND VNB VPB VPWR X
.ends

* Black-box entry subcircuit for sky130_fd_sc_hd__clkbuf_8 abstract view
.subckt sky130_fd_sc_hd__clkbuf_8 A VGND VNB VPB VPWR X
.ends

* Black-box entry subcircuit for sky130_fd_sc_hd__nand3_1 abstract view
.subckt sky130_fd_sc_hd__nand3_1 A B C VGND VNB VPB VPWR Y
.ends

* Black-box entry subcircuit for sky130_fd_sc_hd__nor4_1 abstract view
.subckt sky130_fd_sc_hd__nor4_1 A B C D VGND VNB VPB VPWR Y
.ends

* Black-box entry subcircuit for sky130_fd_sc_hd__a31oi_1 abstract view
.subckt sky130_fd_sc_hd__a31oi_1 A1 A2 A3 B1 VGND VNB VPB VPWR Y
.ends

* Black-box entry subcircuit for sky130_fd_sc_hd__xor2_1 abstract view
.subckt sky130_fd_sc_hd__xor2_1 A B VGND VNB VPB VPWR X
.ends

* Black-box entry subcircuit for sky130_fd_sc_hd__nand4_1 abstract view
.subckt sky130_fd_sc_hd__nand4_1 A B C D VGND VNB VPB VPWR Y
.ends

* Black-box entry subcircuit for sky130_fd_sc_hd__clkbuf_4 abstract view
.subckt sky130_fd_sc_hd__clkbuf_4 A VGND VNB VPB VPWR X
.ends

* Black-box entry subcircuit for sky130_fd_sc_hd__xnor2_2 abstract view
.subckt sky130_fd_sc_hd__xnor2_2 A B VGND VNB VPB VPWR Y
.ends

* Black-box entry subcircuit for sky130_fd_sc_hd__nor3_1 abstract view
.subckt sky130_fd_sc_hd__nor3_1 A B C VGND VNB VPB VPWR Y
.ends

* Black-box entry subcircuit for sky130_fd_sc_hd__nand4b_1 abstract view
.subckt sky130_fd_sc_hd__nand4b_1 A_N B C D VGND VNB VPB VPWR Y
.ends

* Black-box entry subcircuit for sky130_fd_sc_hd__o22a_1 abstract view
.subckt sky130_fd_sc_hd__o22a_1 A1 A2 B1 B2 VGND VNB VPB VPWR X
.ends

* Black-box entry subcircuit for sky130_fd_sc_hd__xnor2_4 abstract view
.subckt sky130_fd_sc_hd__xnor2_4 A B VGND VNB VPB VPWR Y
.ends

* Black-box entry subcircuit for sky130_fd_sc_hd__inv_4 abstract view
.subckt sky130_fd_sc_hd__inv_4 A VGND VNB VPB VPWR Y
.ends

* Black-box entry subcircuit for sky130_fd_sc_hd__and2_1 abstract view
.subckt sky130_fd_sc_hd__and2_1 A B VGND VNB VPB VPWR X
.ends

* Black-box entry subcircuit for sky130_fd_sc_hd__dlymetal6s2s_1 abstract view
.subckt sky130_fd_sc_hd__dlymetal6s2s_1 A VGND VNB VPB VPWR X
.ends

* Black-box entry subcircuit for sky130_fd_sc_hd__bufinv_16 abstract view
.subckt sky130_fd_sc_hd__bufinv_16 A VGND VNB VPB VPWR Y
.ends

* Black-box entry subcircuit for sky130_fd_sc_hd__a21boi_1 abstract view
.subckt sky130_fd_sc_hd__a21boi_1 A1 A2 B1_N VGND VNB VPB VPWR Y
.ends

* Black-box entry subcircuit for sky130_fd_sc_hd__clkbuf_2 abstract view
.subckt sky130_fd_sc_hd__clkbuf_2 A VGND VNB VPB VPWR X
.ends

* Black-box entry subcircuit for sky130_fd_sc_hd__o211a_1 abstract view
.subckt sky130_fd_sc_hd__o211a_1 A1 A2 B1 C1 VGND VNB VPB VPWR X
.ends

* Black-box entry subcircuit for sky130_fd_sc_hd__and3b_1 abstract view
.subckt sky130_fd_sc_hd__and3b_1 A_N B C VGND VNB VPB VPWR X
.ends

* Black-box entry subcircuit for sky130_fd_sc_hd__o31ai_1 abstract view
.subckt sky130_fd_sc_hd__o31ai_1 A1 A2 A3 B1 VGND VNB VPB VPWR Y
.ends

* Black-box entry subcircuit for sky130_fd_sc_hd__buf_4 abstract view
.subckt sky130_fd_sc_hd__buf_4 A VGND VNB VPB VPWR X
.ends

* Black-box entry subcircuit for sky130_fd_sc_hd__clkinv_2 abstract view
.subckt sky130_fd_sc_hd__clkinv_2 A VGND VNB VPB VPWR Y
.ends

* Black-box entry subcircuit for sky130_fd_sc_hd__a211o_1 abstract view
.subckt sky130_fd_sc_hd__a211o_1 A1 A2 B1 C1 VGND VNB VPB VPWR X
.ends

* Black-box entry subcircuit for sky130_fd_sc_hd__nand3b_1 abstract view
.subckt sky130_fd_sc_hd__nand3b_1 A_N B C VGND VNB VPB VPWR Y
.ends

* Black-box entry subcircuit for sky130_fd_sc_hd__nand4_2 abstract view
.subckt sky130_fd_sc_hd__nand4_2 A B C D VGND VNB VPB VPWR Y
.ends

* Black-box entry subcircuit for sky130_fd_sc_hd__a21bo_1 abstract view
.subckt sky130_fd_sc_hd__a21bo_1 A1 A2 B1_N VGND VNB VPB VPWR X
.ends

* Black-box entry subcircuit for sky130_fd_sc_hd__xor2_4 abstract view
.subckt sky130_fd_sc_hd__xor2_4 A B VGND VNB VPB VPWR X
.ends

* Black-box entry subcircuit for sky130_fd_sc_hd__or4_1 abstract view
.subckt sky130_fd_sc_hd__or4_1 A B C D VGND VNB VPB VPWR X
.ends

* Black-box entry subcircuit for sky130_fd_sc_hd__clkbuf_1 abstract view
.subckt sky130_fd_sc_hd__clkbuf_1 A VGND VNB VPB VPWR X
.ends

* Black-box entry subcircuit for sky130_fd_sc_hd__buf_1 abstract view
.subckt sky130_fd_sc_hd__buf_1 A VGND VNB VPB VPWR X
.ends

* Black-box entry subcircuit for sky130_fd_sc_hd__dfrtp_2 abstract view
.subckt sky130_fd_sc_hd__dfrtp_2 CLK D RESET_B VGND VNB VPB VPWR Q
.ends

* Black-box entry subcircuit for sky130_fd_sc_hd__dfstp_2 abstract view
.subckt sky130_fd_sc_hd__dfstp_2 CLK D SET_B VGND VNB VPB VPWR Q
.ends

* Black-box entry subcircuit for sky130_fd_sc_hd__nand2b_1 abstract view
.subckt sky130_fd_sc_hd__nand2b_1 A_N B VGND VNB VPB VPWR Y
.ends

* Black-box entry subcircuit for sky130_fd_sc_hd__dfstp_4 abstract view
.subckt sky130_fd_sc_hd__dfstp_4 CLK D SET_B VGND VNB VPB VPWR Q
.ends

* Black-box entry subcircuit for sky130_fd_sc_hd__a41o_1 abstract view
.subckt sky130_fd_sc_hd__a41o_1 A1 A2 A3 A4 B1 VGND VNB VPB VPWR X
.ends

* Black-box entry subcircuit for sky130_fd_sc_hd__and4_2 abstract view
.subckt sky130_fd_sc_hd__and4_2 A B C D VGND VNB VPB VPWR X
.ends

* Black-box entry subcircuit for sky130_fd_sc_hd__and4bb_1 abstract view
.subckt sky130_fd_sc_hd__and4bb_1 A_N B_N C D VGND VNB VPB VPWR X
.ends

* Black-box entry subcircuit for sky130_fd_sc_hd__o22ai_1 abstract view
.subckt sky130_fd_sc_hd__o22ai_1 A1 A2 B1 B2 VGND VNB VPB VPWR Y
.ends

* Black-box entry subcircuit for sky130_fd_sc_hd__a211oi_1 abstract view
.subckt sky130_fd_sc_hd__a211oi_1 A1 A2 B1 C1 VGND VNB VPB VPWR Y
.ends

.subckt ethernet_fcs_checker VGND VPWR clk data_in[0] data_in[1] data_in[2] data_in[3]
+ data_in[4] data_in[5] data_in[6] data_in[7] fcs_error fcs_valid frame_len[0] frame_len[10]
+ frame_len[11] frame_len[12] frame_len[13] frame_len[14] frame_len[15] frame_len[1]
+ frame_len[2] frame_len[3] frame_len[4] frame_len[5] frame_len[6] frame_len[7] frame_len[8]
+ frame_len[9] in_eop in_sop in_valid rst
XFILLER_39_233 VGND VGND VPWR VPWR sky130_fd_sc_hd__decap_3
XFILLER_22_100 VPWR VGND VPWR VGND sky130_ef_sc_hd__decap_12
XFILLER_7_7 VGND VGND VPWR VPWR sky130_fd_sc_hd__decap_6
XFILLER_45_225 VPWR VGND VPWR VGND sky130_ef_sc_hd__decap_12
X_432_ crc_reg\[29\] crc_reg\[23\] VGND VGND VPWR VPWR _136_ sky130_fd_sc_hd__nand2_1
XFILLER_26_85 VGND VGND VPWR VPWR sky130_fd_sc_hd__decap_8
X_501_ crc_reg\[31\] net60 net6 VGND VGND VPWR VPWR _198_ sky130_fd_sc_hd__o21bai_1
XFILLER_9_104 VGND VGND VPWR VPWR sky130_fd_sc_hd__decap_8
XTAP_TAPCELL_ROW_14_161 VGND VPWR sky130_fd_sc_hd__tapvpwrvgnd_1
XTAP_TAPCELL_ROW_6_129 VGND VPWR sky130_fd_sc_hd__tapvpwrvgnd_1
XFILLER_42_217 VGND VGND VPWR VPWR sky130_fd_sc_hd__decap_3
XFILLER_27_225 VPWR VGND VPWR VGND sky130_ef_sc_hd__decap_12
XFILLER_27_269 VGND VGND VPWR VPWR sky130_fd_sc_hd__decap_8
XFILLER_12_54 VGND VGND VPWR VPWR sky130_fd_sc_hd__decap_6
XFILLER_12_76 VGND VGND VPWR VPWR sky130_fd_sc_hd__decap_8
XFILLER_18_214 VGND VGND VPWR VPWR sky130_fd_sc_hd__decap_4
XFILLER_41_272 VGND VGND VPWR VPWR sky130_fd_sc_hd__decap_6
XFILLER_24_217 VGND VGND VPWR VPWR sky130_fd_sc_hd__fill_1
XTAP_TAPCELL_ROW_2_110 VGND VPWR sky130_fd_sc_hd__tapvpwrvgnd_1
XFILLER_23_272 VGND VGND VPWR VPWR sky130_fd_sc_hd__decap_6
XTAP_TAPCELL_ROW_25_212 VGND VPWR sky130_fd_sc_hd__tapvpwrvgnd_1
X_895_ clknet_3_3__leaf_clk _107_ _043_ VGND VGND VPWR VPWR crc_reg\[7\] sky130_fd_sc_hd__dfstp_1
XFILLER_0_57 VGND VGND VPWR VPWR sky130_fd_sc_hd__fill_2
XFILLER_9_55 VGND VGND VPWR VPWR sky130_fd_sc_hd__fill_1
XFILLER_9_77 VGND VGND VPWR VPWR sky130_fd_sc_hd__decap_8
XFILLER_12_209 VGND VGND VPWR VPWR sky130_fd_sc_hd__fill_2
XFILLER_20_253 VPWR VGND VPWR VGND sky130_ef_sc_hd__decap_12
XFILLER_18_53 VGND VGND VPWR VPWR sky130_fd_sc_hd__decap_4
XFILLER_18_97 VPWR VGND VPWR VGND sky130_ef_sc_hd__decap_12
X_680_ crc_reg\[3\] _355_ net56 VGND VGND VPWR VPWR _103_ sky130_fd_sc_hd__mux2_1
XFILLER_34_41 VGND VGND VPWR VPWR sky130_fd_sc_hd__fill_2
XFILLER_7_268 VGND VGND VPWR VPWR sky130_fd_sc_hd__fill_2
XFILLER_7_257 VGND VGND VPWR VPWR sky130_fd_sc_hd__fill_2
XFILLER_38_139 VGND VGND VPWR VPWR sky130_fd_sc_hd__fill_1
X_878_ clknet_3_0__leaf_clk _090_ _026_ VGND VGND VPWR VPWR net27 sky130_fd_sc_hd__dfrtp_1
XFILLER_46_161 VGND VGND VPWR VPWR sky130_fd_sc_hd__decap_6
X_732_ net59 _369_ VGND VGND VPWR VPWR _395_ sky130_fd_sc_hd__nor2_1
X_801_ net45 VGND VGND VPWR VPWR _015_ sky130_fd_sc_hd__inv_2
XFILLER_45_51 VGND VGND VPWR VPWR sky130_fd_sc_hd__decap_4
X_663_ net1 _196_ VGND VGND VPWR VPWR _341_ sky130_fd_sc_hd__xnor2_1
X_594_ _271_ _272_ _275_ VGND VGND VPWR VPWR _280_ sky130_fd_sc_hd__a21oi_1
XFILLER_13_3 VPWR VGND VPWR VGND sky130_ef_sc_hd__decap_12
XFILLER_34_197 VPWR VGND VPWR VGND sky130_ef_sc_hd__decap_12
XFILLER_34_164 VGND VGND VPWR VPWR sky130_fd_sc_hd__fill_1
XFILLER_40_156 VPWR VGND VPWR VGND sky130_ef_sc_hd__decap_12
XFILLER_15_87 VGND VGND VPWR VPWR sky130_fd_sc_hd__fill_2
XFILLER_31_53 VGND VGND VPWR VPWR sky130_fd_sc_hd__decap_3
Xoutput20 net20 VGND VGND VPWR VPWR frame_len[14] sky130_fd_sc_hd__buf_2
X_715_ len_cnt\[12\] _372_ _383_ VGND VGND VPWR VPWR _384_ sky130_fd_sc_hd__o21a_1
XFILLER_16_120 VGND VGND VPWR VPWR sky130_fd_sc_hd__decap_4
XFILLER_16_153 VPWR VGND VPWR VGND sky130_ef_sc_hd__decap_12
X_646_ _325_ _326_ _299_ VGND VGND VPWR VPWR _327_ sky130_fd_sc_hd__o21ai_1
X_577_ _183_ _239_ VGND VGND VPWR VPWR _264_ sky130_fd_sc_hd__xnor2_1
XFILLER_22_112 VPWR VGND VPWR VGND sky130_ef_sc_hd__decap_12
XFILLER_22_156 VGND VGND VPWR VPWR sky130_fd_sc_hd__fill_1
XFILLER_22_178 VPWR VGND VPWR VGND sky130_ef_sc_hd__decap_12
X_500_ net33 net61 net6 VGND VGND VPWR VPWR _197_ sky130_fd_sc_hd__or3b_1
XFILLER_45_237 VPWR VGND VPWR VGND sky130_ef_sc_hd__decap_12
X_431_ crc_reg\[29\] crc_reg\[23\] VGND VGND VPWR VPWR _135_ sky130_fd_sc_hd__or2_1
XFILLER_13_145 VGND VGND VPWR VPWR sky130_fd_sc_hd__fill_2
XFILLER_26_42 VGND VGND VPWR VPWR sky130_fd_sc_hd__fill_2
XFILLER_26_53 VPWR VGND VPWR VGND sky130_ef_sc_hd__decap_12
Xclkbuf_3_6__f_clk clknet_0_clk VGND VGND VPWR VPWR clknet_3_6__leaf_clk sky130_fd_sc_hd__clkbuf_16
XFILLER_42_85 VGND VGND VPWR VPWR sky130_fd_sc_hd__decap_8
XFILLER_42_41 VPWR VGND VPWR VGND sky130_ef_sc_hd__decap_12
XFILLER_3_35 VGND VGND VPWR VPWR sky130_fd_sc_hd__fill_1
X_629_ net8 net6 VGND VGND VPWR VPWR _312_ sky130_fd_sc_hd__xor2_2
XTAP_TAPCELL_ROW_14_162 VGND VPWR sky130_fd_sc_hd__tapvpwrvgnd_1
XTAP_TAPCELL_ROW_37_265 VGND VPWR sky130_fd_sc_hd__tapvpwrvgnd_1
XFILLER_27_237 VGND VGND VPWR VPWR sky130_fd_sc_hd__fill_2
XTAP_TAPCELL_ROW_42_290 VGND VPWR sky130_fd_sc_hd__tapvpwrvgnd_1
XPHY_EDGE_ROW_12_Right_12 VGND VGND VPWR VPWR sky130_fd_sc_hd__decap_3
XTAP_TAPCELL_ROW_2_111 VGND VPWR sky130_fd_sc_hd__tapvpwrvgnd_1
XFILLER_15_207 VGND VGND VPWR VPWR sky130_fd_sc_hd__fill_1
XPHY_EDGE_ROW_21_Right_21 VGND VGND VPWR VPWR sky130_fd_sc_hd__decap_3
XTAP_TAPCELL_ROW_25_213 VGND VPWR sky130_fd_sc_hd__tapvpwrvgnd_1
XPHY_EDGE_ROW_30_Right_30 VGND VGND VPWR VPWR sky130_fd_sc_hd__decap_3
XFILLER_2_144 VGND VGND VPWR VPWR sky130_fd_sc_hd__fill_2
X_894_ clknet_3_6__leaf_clk _106_ _042_ VGND VGND VPWR VPWR crc_reg\[6\] sky130_fd_sc_hd__dfstp_1
XFILLER_14_251 VGND VGND VPWR VPWR sky130_fd_sc_hd__fill_1
XTAP_TAPCELL_ROW_31_238 VGND VPWR sky130_fd_sc_hd__tapvpwrvgnd_1
XFILLER_43_3 VPWR VGND VPWR VGND sky130_ef_sc_hd__decap_12
XFILLER_20_265 VPWR VGND VPWR VGND sky130_ef_sc_hd__decap_12
XFILLER_18_65 VPWR VGND VPWR VGND sky130_ef_sc_hd__decap_12
XFILLER_7_225 VGND VGND VPWR VPWR sky130_fd_sc_hd__decap_8
XFILLER_11_276 VGND VGND VPWR VPWR sky130_fd_sc_hd__fill_2
X_877_ clknet_3_0__leaf_clk _089_ _025_ VGND VGND VPWR VPWR net26 sky130_fd_sc_hd__dfrtp_1
XFILLER_46_195 VGND VGND VPWR VPWR sky130_fd_sc_hd__fill_1
XPHY_EDGE_ROW_28_Left_75 VGND VGND VPWR VPWR sky130_fd_sc_hd__decap_3
XPHY_EDGE_ROW_12_Left_59 VGND VGND VPWR VPWR sky130_fd_sc_hd__decap_3
XFILLER_37_173 VGND VGND VPWR VPWR sky130_fd_sc_hd__fill_1
X_800_ net45 VGND VGND VPWR VPWR _014_ sky130_fd_sc_hd__inv_2
X_731_ net67 _394_ net31 VGND VGND VPWR VPWR _091_ sky130_fd_sc_hd__mux2_1
Xhold20 len_cnt\[15\] VGND VGND VPWR VPWR net82 sky130_fd_sc_hd__dlygate4sd3_1
X_662_ net41 _339_ _340_ _336_ VGND VGND VPWR VPWR _106_ sky130_fd_sc_hd__o31a_1
XFILLER_28_195 VGND VGND VPWR VPWR sky130_fd_sc_hd__fill_1
X_593_ _271_ _272_ _275_ VGND VGND VPWR VPWR _279_ sky130_fd_sc_hd__and3_1
XFILLER_6_68 VPWR VGND VPWR VGND sky130_ef_sc_hd__decap_12
XFILLER_19_162 VGND VGND VPWR VPWR sky130_fd_sc_hd__decap_6
XFILLER_34_187 VGND VGND VPWR VPWR sky130_fd_sc_hd__decap_8
XPHY_EDGE_ROW_6_Right_6 VGND VGND VPWR VPWR sky130_fd_sc_hd__decap_3
XFILLER_15_55 VGND VGND VPWR VPWR sky130_fd_sc_hd__fill_1
XFILLER_40_168 VGND VGND VPWR VPWR sky130_fd_sc_hd__fill_1
XFILLER_40_146 VGND VGND VPWR VPWR sky130_fd_sc_hd__decap_3
XFILLER_15_77 VGND VGND VPWR VPWR sky130_fd_sc_hd__decap_4
XFILLER_31_76 VPWR VGND VPWR VGND sky130_ef_sc_hd__decap_12
XFILLER_0_253 VPWR VGND VPWR VGND sky130_ef_sc_hd__decap_12
Xoutput21 net21 VGND VGND VPWR VPWR frame_len[15] sky130_fd_sc_hd__buf_2
X_714_ net58 _373_ VGND VGND VPWR VPWR _383_ sky130_fd_sc_hd__nor2_1
XFILLER_16_132 VGND VGND VPWR VPWR sky130_fd_sc_hd__decap_8
X_645_ crc_reg\[0\] _300_ VGND VGND VPWR VPWR _326_ sky130_fd_sc_hd__nor2_1
XFILLER_16_165 VPWR VGND VPWR VGND sky130_ef_sc_hd__decap_12
X_576_ net52 crc_reg\[14\] VGND VGND VPWR VPWR _263_ sky130_fd_sc_hd__or2_1
XFILLER_31_113 VPWR VGND VPWR VGND sky130_ef_sc_hd__decap_12
XFILLER_31_135 VGND VGND VPWR VPWR sky130_fd_sc_hd__decap_8
XFILLER_22_124 VGND VGND VPWR VPWR sky130_fd_sc_hd__decap_3
XTAP_TAPCELL_ROW_9_139 VGND VPWR sky130_fd_sc_hd__tapvpwrvgnd_1
XPHY_EDGE_ROW_15_Left_62 VGND VGND VPWR VPWR sky130_fd_sc_hd__decap_3
XFILLER_45_249 VPWR VGND VPWR VGND sky130_ef_sc_hd__decap_12
XFILLER_42_53 VGND VGND VPWR VPWR sky130_fd_sc_hd__decap_8
X_430_ net42 VGND VGND VPWR VPWR _002_ sky130_fd_sc_hd__inv_2
XFILLER_13_102 VGND VGND VPWR VPWR sky130_fd_sc_hd__decap_8
XFILLER_13_113 VPWR VGND VPWR VGND sky130_ef_sc_hd__decap_12
XFILLER_26_65 VGND VGND VPWR VPWR sky130_fd_sc_hd__decap_4
XFILLER_36_227 VPWR VGND VPWR VGND sky130_ef_sc_hd__decap_12
X_628_ net3 _310_ VGND VGND VPWR VPWR _311_ sky130_fd_sc_hd__xnor2_1
X_559_ net55 net88 _248_ VGND VGND VPWR VPWR _117_ sky130_fd_sc_hd__o21ba_1
XTAP_TAPCELL_ROW_14_163 VGND VPWR sky130_fd_sc_hd__tapvpwrvgnd_1
XFILLER_27_205 VGND VGND VPWR VPWR sky130_fd_sc_hd__decap_6
XTAP_TAPCELL_ROW_37_266 VGND VPWR sky130_fd_sc_hd__tapvpwrvgnd_1
XFILLER_35_271 VGND VGND VPWR VPWR sky130_fd_sc_hd__decap_6
XFILLER_10_149 VPWR VGND VPWR VGND sky130_ef_sc_hd__decap_12
XTAP_TAPCELL_ROW_20_188 VGND VPWR sky130_fd_sc_hd__tapvpwrvgnd_1
XPHY_EDGE_ROW_0_Left_47 VGND VGND VPWR VPWR sky130_fd_sc_hd__decap_3
XFILLER_37_97 VGND VGND VPWR VPWR sky130_fd_sc_hd__fill_1
XFILLER_5_186 VPWR VGND VPWR VGND sky130_ef_sc_hd__decap_12
XTAP_TAPCELL_ROW_42_291 VGND VPWR sky130_fd_sc_hd__tapvpwrvgnd_1
XPHY_EDGE_ROW_42_Left_89 VGND VGND VPWR VPWR sky130_fd_sc_hd__decap_3
XTAP_TAPCELL_ROW_25_214 VGND VPWR sky130_fd_sc_hd__tapvpwrvgnd_1
XFILLER_3_3 VPWR VGND VPWR VGND sky130_ef_sc_hd__decap_12
XFILLER_0_15 VPWR VGND VPWR VGND sky130_ef_sc_hd__decap_12
X_893_ clknet_3_6__leaf_clk _105_ _041_ VGND VGND VPWR VPWR crc_reg\[5\] sky130_fd_sc_hd__dfstp_1
XFILLER_0_37 VGND VGND VPWR VPWR sky130_fd_sc_hd__fill_1
XFILLER_9_57 VPWR VGND VPWR VGND sky130_ef_sc_hd__decap_12
XTAP_TAPCELL_ROW_31_239 VGND VPWR sky130_fd_sc_hd__tapvpwrvgnd_1
XFILLER_36_3 VPWR VGND VPWR VGND sky130_ef_sc_hd__decap_12
XFILLER_20_277 VGND VGND VPWR VPWR sky130_fd_sc_hd__fill_1
XFILLER_18_77 VGND VGND VPWR VPWR sky130_fd_sc_hd__decap_6
XFILLER_11_244 VPWR VGND VPWR VGND sky130_ef_sc_hd__decap_12
XFILLER_34_98 VGND VGND VPWR VPWR sky130_fd_sc_hd__fill_2
XFILLER_46_141 VGND VGND VPWR VPWR sky130_fd_sc_hd__fill_2
XPHY_EDGE_ROW_3_Left_50 VGND VGND VPWR VPWR sky130_fd_sc_hd__decap_3
X_876_ clknet_3_0__leaf_clk _088_ _024_ VGND VGND VPWR VPWR net25 sky130_fd_sc_hd__dfrtp_1
XFILLER_37_141 VGND VGND VPWR VPWR sky130_fd_sc_hd__decap_8
XPHY_EDGE_ROW_45_Left_92 VGND VGND VPWR VPWR sky130_fd_sc_hd__decap_3
X_592_ _276_ _277_ VGND VGND VPWR VPWR _278_ sky130_fd_sc_hd__nand2_1
X_730_ len_cnt\[7\] _369_ _393_ VGND VGND VPWR VPWR _394_ sky130_fd_sc_hd__o21a_1
Xhold21 len_cnt\[12\] VGND VGND VPWR VPWR net83 sky130_fd_sc_hd__dlygate4sd3_1
Xhold10 net29 VGND VGND VPWR VPWR net72 sky130_fd_sc_hd__dlygate4sd3_1
X_661_ _318_ _319_ _338_ VGND VGND VPWR VPWR _340_ sky130_fd_sc_hd__and3_1
XFILLER_28_141 VPWR VGND VPWR VGND sky130_ef_sc_hd__decap_12
X_859_ clknet_3_0__leaf_clk _073_ _007_ VGND VGND VPWR VPWR len_cnt\[5\] sky130_fd_sc_hd__dfrtp_1
XFILLER_25_111 VGND VGND VPWR VPWR sky130_fd_sc_hd__fill_1
XFILLER_31_88 VPWR VGND VPWR VGND sky130_ef_sc_hd__decap_12
XFILLER_0_265 VPWR VGND VPWR VGND sky130_ef_sc_hd__decap_12
Xoutput22 net22 VGND VGND VPWR VPWR frame_len[1] sky130_fd_sc_hd__buf_2
X_713_ net70 _382_ net31 VGND VGND VPWR VPWR _097_ sky130_fd_sc_hd__mux2_1
X_644_ crc_reg\[0\] _300_ net62 VGND VGND VPWR VPWR _325_ sky130_fd_sc_hd__a21o_1
X_575_ net38 _261_ _262_ _255_ VGND VGND VPWR VPWR _115_ sky130_fd_sc_hd__o31a_1
XFILLER_16_177 VGND VGND VPWR VPWR sky130_fd_sc_hd__decap_8
XFILLER_31_125 VGND VGND VPWR VPWR sky130_fd_sc_hd__decap_3
XFILLER_31_169 VPWR VGND VPWR VGND sky130_ef_sc_hd__decap_12
XFILLER_39_225 VGND VGND VPWR VPWR sky130_fd_sc_hd__decap_8
XFILLER_30_191 VGND VGND VPWR VPWR sky130_fd_sc_hd__decap_4
XFILLER_9_129 VGND VGND VPWR VPWR sky130_fd_sc_hd__fill_1
XFILLER_3_15 VPWR VGND VPWR VGND sky130_ef_sc_hd__decap_12
XFILLER_36_239 VPWR VGND VPWR VGND sky130_ef_sc_hd__decap_12
X_558_ net55 _246_ _247_ VGND VGND VPWR VPWR _248_ sky130_fd_sc_hd__and3_1
X_627_ crc_reg\[2\] net62 VGND VGND VPWR VPWR _310_ sky130_fd_sc_hd__or2_1
XFILLER_8_184 VPWR VGND VPWR VGND sky130_ef_sc_hd__decap_12
XTAP_TAPCELL_ROW_14_164 VGND VPWR sky130_fd_sc_hd__tapvpwrvgnd_1
X_489_ net38 _186_ _187_ _177_ VGND VGND VPWR VPWR _126_ sky130_fd_sc_hd__o31a_1
XFILLER_42_209 VGND VGND VPWR VPWR sky130_fd_sc_hd__decap_8
XTAP_TAPCELL_ROW_37_267 VGND VPWR sky130_fd_sc_hd__tapvpwrvgnd_1
XTAP_TAPCELL_ROW_20_189 VGND VPWR sky130_fd_sc_hd__tapvpwrvgnd_1
XTAP_TAPCELL_ROW_5_121 VGND VPWR sky130_fd_sc_hd__tapvpwrvgnd_1
XFILLER_37_65 VPWR VGND VPWR VGND sky130_ef_sc_hd__decap_12
XFILLER_37_54 VGND VGND VPWR VPWR sky130_fd_sc_hd__fill_2
XFILLER_5_198 VGND VGND VPWR VPWR sky130_fd_sc_hd__decap_3
XFILLER_24_209 VGND VGND VPWR VPWR sky130_fd_sc_hd__decap_3
XFILLER_17_250 VGND VGND VPWR VPWR sky130_fd_sc_hd__decap_3
XFILLER_32_253 VPWR VGND VPWR VGND sky130_ef_sc_hd__decap_12
X_892_ clknet_3_7__leaf_clk _104_ _040_ VGND VGND VPWR VPWR crc_reg\[4\] sky130_fd_sc_hd__dfstp_1
XFILLER_0_27 VGND VGND VPWR VPWR sky130_fd_sc_hd__fill_1
XFILLER_0_49 VGND VGND VPWR VPWR sky130_fd_sc_hd__decap_3
XFILLER_9_69 VGND VGND VPWR VPWR sky130_fd_sc_hd__fill_2
XFILLER_14_253 VGND VGND VPWR VPWR sky130_fd_sc_hd__fill_2
XFILLER_14_275 VGND VGND VPWR VPWR sky130_fd_sc_hd__decap_3
XFILLER_29_3 VPWR VGND VPWR VGND sky130_ef_sc_hd__decap_12
XFILLER_20_201 VPWR VGND VPWR VGND sky130_ef_sc_hd__decap_12
XFILLER_7_249 VGND VGND VPWR VPWR sky130_fd_sc_hd__decap_8
XFILLER_46_175 VPWR VGND VPWR VGND sky130_ef_sc_hd__decap_12
X_875_ clknet_3_0__leaf_clk _087_ _023_ VGND VGND VPWR VPWR net24 sky130_fd_sc_hd__dfrtp_1
XFILLER_37_131 VGND VGND VPWR VPWR sky130_fd_sc_hd__decap_3
XFILLER_1_92 VGND VGND VPWR VPWR sky130_fd_sc_hd__decap_6
Xhold22 len_cnt\[5\] VGND VGND VPWR VPWR net84 sky130_fd_sc_hd__dlygate4sd3_1
Xhold11 net27 VGND VGND VPWR VPWR net73 sky130_fd_sc_hd__dlygate4sd3_1
XFILLER_20_79 VGND VGND VPWR VPWR sky130_fd_sc_hd__decap_4
X_591_ crc_reg\[27\] net62 _201_ VGND VGND VPWR VPWR _277_ sky130_fd_sc_hd__or3_1
X_660_ _318_ _319_ _338_ VGND VGND VPWR VPWR _339_ sky130_fd_sc_hd__a21oi_1
XFILLER_28_153 VPWR VGND VPWR VGND sky130_ef_sc_hd__decap_12
XFILLER_29_55 VGND VGND VPWR VPWR sky130_fd_sc_hd__fill_1
XFILLER_43_189 VPWR VGND VPWR VGND sky130_ef_sc_hd__decap_12
XFILLER_43_167 VGND VGND VPWR VPWR sky130_fd_sc_hd__fill_1
XFILLER_6_15 VPWR VGND VPWR VGND sky130_ef_sc_hd__decap_12
X_858_ clknet_3_0__leaf_clk _072_ _006_ VGND VGND VPWR VPWR len_cnt\[4\] sky130_fd_sc_hd__dfrtp_1
XFILLER_19_131 VPWR VGND VPWR VGND sky130_ef_sc_hd__decap_12
X_789_ net42 VGND VGND VPWR VPWR _003_ sky130_fd_sc_hd__inv_2
XFILLER_34_156 VGND VGND VPWR VPWR sky130_fd_sc_hd__decap_8
XFILLER_25_101 VGND VGND VPWR VPWR sky130_fd_sc_hd__decap_3
XFILLER_40_137 VGND VGND VPWR VPWR sky130_fd_sc_hd__decap_3
XFILLER_15_57 VPWR VGND VPWR VGND sky130_ef_sc_hd__decap_12
XFILLER_25_167 VGND VGND VPWR VPWR sky130_fd_sc_hd__fill_1
Xoutput23 net23 VGND VGND VPWR VPWR frame_len[2] sky130_fd_sc_hd__buf_2
XFILLER_0_277 VGND VGND VPWR VPWR sky130_fd_sc_hd__fill_1
XFILLER_0_211 VGND VGND VPWR VPWR sky130_fd_sc_hd__fill_2
X_712_ len_cnt\[13\] _373_ _381_ VGND VGND VPWR VPWR _382_ sky130_fd_sc_hd__o21a_1
X_643_ net38 _322_ _323_ _324_ VGND VGND VPWR VPWR _109_ sky130_fd_sc_hd__o31a_1
X_574_ net34 _258_ _259_ _260_ VGND VGND VPWR VPWR _262_ sky130_fd_sc_hd__and4_1
XFILLER_11_3 VPWR VGND VPWR VGND sky130_ef_sc_hd__decap_12
XFILLER_22_148 VGND VGND VPWR VPWR sky130_fd_sc_hd__decap_8
XFILLER_13_137 VGND VGND VPWR VPWR sky130_fd_sc_hd__decap_8
XFILLER_3_27 VGND VGND VPWR VPWR sky130_fd_sc_hd__decap_8
XFILLER_44_251 VGND VGND VPWR VPWR sky130_fd_sc_hd__fill_1
X_557_ net35 _243_ _244_ _245_ VGND VGND VPWR VPWR _247_ sky130_fd_sc_hd__a31o_1
X_488_ net34 _181_ _182_ _185_ VGND VGND VPWR VPWR _187_ sky130_fd_sc_hd__and4_1
X_626_ net62 _307_ VGND VGND VPWR VPWR _309_ sky130_fd_sc_hd__nor2_1
XTAP_TAPCELL_ROW_14_165 VGND VPWR sky130_fd_sc_hd__tapvpwrvgnd_1
XTAP_TAPCELL_ROW_37_268 VGND VPWR sky130_fd_sc_hd__tapvpwrvgnd_1
XTAP_TAPCELL_ROW_5_122 VGND VPWR sky130_fd_sc_hd__tapvpwrvgnd_1
XFILLER_18_218 VGND VGND VPWR VPWR sky130_fd_sc_hd__fill_1
XFILLER_41_210 VGND VGND VPWR VPWR sky130_fd_sc_hd__fill_1
XFILLER_37_77 VPWR VGND VPWR VGND sky130_ef_sc_hd__decap_12
XFILLER_26_251 VGND VGND VPWR VPWR sky130_fd_sc_hd__fill_1
XTAP_TAPCELL_ROW_28_224 VGND VPWR sky130_fd_sc_hd__tapvpwrvgnd_1
XFILLER_5_122 VGND VGND VPWR VPWR sky130_fd_sc_hd__decap_6
X_609_ net4 _293_ VGND VGND VPWR VPWR _294_ sky130_fd_sc_hd__xnor2_1
XFILLER_17_273 VGND VGND VPWR VPWR sky130_fd_sc_hd__fill_1
XFILLER_32_265 VPWR VGND VPWR VGND sky130_ef_sc_hd__decap_12
XFILLER_4_92 VGND VGND VPWR VPWR sky130_fd_sc_hd__decap_6
X_891_ clknet_3_6__leaf_clk _103_ _039_ VGND VGND VPWR VPWR crc_reg\[3\] sky130_fd_sc_hd__dfstp_1
XFILLER_9_15 VPWR VGND VPWR VGND sky130_ef_sc_hd__decap_12
XFILLER_1_180 VGND VGND VPWR VPWR sky130_fd_sc_hd__decap_3
XFILLER_20_213 VGND VGND VPWR VPWR sky130_fd_sc_hd__decap_3
XFILLER_18_57 VGND VGND VPWR VPWR sky130_fd_sc_hd__fill_1
XFILLER_7_239 VGND VGND VPWR VPWR sky130_fd_sc_hd__fill_1
Xclkload0 clknet_3_1__leaf_clk VGND VGND VPWR VPWR clkload0/X sky130_fd_sc_hd__clkbuf_8
X_874_ clknet_3_1__leaf_clk _086_ _022_ VGND VGND VPWR VPWR net23 sky130_fd_sc_hd__dfrtp_1
XFILLER_46_187 VGND VGND VPWR VPWR sky130_fd_sc_hd__decap_8
XTAP_TAPCELL_ROW_44_300 VGND VPWR sky130_fd_sc_hd__tapvpwrvgnd_1
XFILLER_41_3 VPWR VGND VPWR VGND sky130_ef_sc_hd__decap_12
Xhold23 len_cnt\[2\] VGND VGND VPWR VPWR net85 sky130_fd_sc_hd__dlygate4sd3_1
Xhold12 net26 VGND VGND VPWR VPWR net74 sky130_fd_sc_hd__dlygate4sd3_1
XFILLER_45_99 VGND VGND VPWR VPWR sky130_fd_sc_hd__fill_1
XFILLER_45_55 VGND VGND VPWR VPWR sky130_fd_sc_hd__fill_1
XFILLER_43_113 VGND VGND VPWR VPWR sky130_fd_sc_hd__fill_2
X_590_ crc_reg\[27\] net36 _201_ VGND VGND VPWR VPWR _276_ sky130_fd_sc_hd__nand3_1
XFILLER_28_165 VGND VGND VPWR VPWR sky130_fd_sc_hd__decap_3
XFILLER_6_38 VGND VGND VPWR VPWR sky130_fd_sc_hd__decap_6
XFILLER_6_27 VGND VGND VPWR VPWR sky130_fd_sc_hd__fill_1
X_857_ clknet_3_0__leaf_clk _071_ _005_ VGND VGND VPWR VPWR len_cnt\[3\] sky130_fd_sc_hd__dfrtp_1
XFILLER_19_143 VPWR VGND VPWR VGND sky130_ef_sc_hd__decap_12
X_788_ _365_ _420_ _421_ _426_ VGND VGND VPWR VPWR _001_ sky130_fd_sc_hd__nor4_1
XFILLER_25_113 VPWR VGND VPWR VGND sky130_ef_sc_hd__decap_12
XFILLER_15_69 VGND VGND VPWR VPWR sky130_fd_sc_hd__decap_3
Xoutput24 net24 VGND VGND VPWR VPWR frame_len[3] sky130_fd_sc_hd__buf_2
Xoutput13 net13 VGND VGND VPWR VPWR fcs_error sky130_fd_sc_hd__buf_2
X_711_ len_cnt\[13\] _373_ net58 VGND VGND VPWR VPWR _381_ sky130_fd_sc_hd__a21oi_1
XFILLER_0_245 VGND VGND VPWR VPWR sky130_fd_sc_hd__decap_3
XFILLER_0_223 VGND VGND VPWR VPWR sky130_fd_sc_hd__fill_1
X_642_ net54 crc_reg\[9\] VGND VGND VPWR VPWR _324_ sky130_fd_sc_hd__or2_1
XFILLER_16_124 VGND VGND VPWR VPWR sky130_fd_sc_hd__fill_1
X_573_ net34 _258_ _259_ _260_ VGND VGND VPWR VPWR _261_ sky130_fd_sc_hd__a31oi_1
XPHY_EDGE_ROW_19_Right_19 VGND VGND VPWR VPWR sky130_fd_sc_hd__decap_3
XFILLER_24_190 VGND VGND VPWR VPWR sky130_fd_sc_hd__decap_6
Xclkbuf_3_1__f_clk clknet_0_clk VGND VGND VPWR VPWR clknet_3_1__leaf_clk sky130_fd_sc_hd__clkbuf_16
XPHY_EDGE_ROW_28_Right_28 VGND VGND VPWR VPWR sky130_fd_sc_hd__decap_3
X_909_ clknet_3_7__leaf_clk _121_ _057_ VGND VGND VPWR VPWR crc_reg\[21\] sky130_fd_sc_hd__dfstp_1
XPHY_EDGE_ROW_37_Right_37 VGND VGND VPWR VPWR sky130_fd_sc_hd__decap_3
XPHY_EDGE_ROW_46_Right_46 VGND VGND VPWR VPWR sky130_fd_sc_hd__decap_3
XFILLER_7_70 VPWR VGND VPWR VGND sky130_ef_sc_hd__decap_12
XFILLER_45_208 VPWR VGND VPWR VGND sky130_ef_sc_hd__decap_12
XFILLER_42_67 VGND VGND VPWR VPWR sky130_fd_sc_hd__decap_8
X_625_ crc_reg\[29\] _307_ VGND VGND VPWR VPWR _308_ sky130_fd_sc_hd__xor2_1
XFILLER_29_271 VGND VGND VPWR VPWR sky130_fd_sc_hd__fill_1
X_487_ net34 _181_ _182_ _185_ VGND VGND VPWR VPWR _186_ sky130_fd_sc_hd__a31oi_1
X_556_ net35 _243_ _244_ _245_ VGND VGND VPWR VPWR _246_ sky130_fd_sc_hd__nand4_1
XPHY_EDGE_ROW_19_Left_66 VGND VGND VPWR VPWR sky130_fd_sc_hd__decap_3
XFILLER_27_219 VGND VGND VPWR VPWR sky130_fd_sc_hd__decap_4
XFILLER_10_108 VPWR VGND VPWR VGND sky130_ef_sc_hd__decap_12
XFILLER_37_89 VGND VGND VPWR VPWR sky130_fd_sc_hd__decap_8
XTAP_TAPCELL_ROW_5_123 VGND VPWR sky130_fd_sc_hd__tapvpwrvgnd_1
XTAP_TAPCELL_ROW_28_225 VGND VPWR sky130_fd_sc_hd__tapvpwrvgnd_1
XFILLER_5_178 VGND VGND VPWR VPWR sky130_fd_sc_hd__fill_1
XFILLER_5_167 VGND VGND VPWR VPWR sky130_fd_sc_hd__fill_1
X_608_ net8 net7 VGND VGND VPWR VPWR _293_ sky130_fd_sc_hd__xor2_2
XFILLER_17_230 VPWR VGND VPWR VGND sky130_ef_sc_hd__decap_12
X_539_ net59 _229_ _230_ _153_ VGND VGND VPWR VPWR _231_ sky130_fd_sc_hd__o31a_1
XFILLER_32_277 VGND VGND VPWR VPWR sky130_fd_sc_hd__fill_1
XTAP_TAPCELL_ROW_33_250 VGND VPWR sky130_fd_sc_hd__tapvpwrvgnd_1
XFILLER_23_233 VGND VGND VPWR VPWR sky130_fd_sc_hd__decap_3
XFILLER_23_47 VGND VGND VPWR VPWR sky130_fd_sc_hd__fill_2
X_890_ clknet_3_6__leaf_clk _102_ _038_ VGND VGND VPWR VPWR crc_reg\[2\] sky130_fd_sc_hd__dfstp_1
XFILLER_0_29 VGND VGND VPWR VPWR sky130_fd_sc_hd__decap_8
XFILLER_9_27 VPWR VGND VPWR VGND sky130_ef_sc_hd__decap_12
XTAP_TAPCELL_ROW_0_94 VGND VPWR sky130_fd_sc_hd__tapvpwrvgnd_1
Xclkload1 clknet_3_2__leaf_clk VGND VGND VPWR VPWR clkload1/X sky130_fd_sc_hd__clkbuf_4
XFILLER_34_46 VGND VGND VPWR VPWR sky130_fd_sc_hd__decap_4
XFILLER_1_3 VPWR VGND VPWR VGND sky130_ef_sc_hd__decap_12
XFILLER_46_133 VGND VGND VPWR VPWR sky130_fd_sc_hd__fill_1
X_873_ clknet_3_1__leaf_clk _085_ _021_ VGND VGND VPWR VPWR net22 sky130_fd_sc_hd__dfrtp_1
XFILLER_34_3 VPWR VGND VPWR VGND sky130_ef_sc_hd__decap_12
XFILLER_37_111 VGND VGND VPWR VPWR sky130_fd_sc_hd__fill_1
XFILLER_20_15 VPWR VGND VPWR VGND sky130_ef_sc_hd__decap_12
Xhold24 len_cnt\[11\] VGND VGND VPWR VPWR net86 sky130_fd_sc_hd__dlygate4sd3_1
Xhold13 net25 VGND VGND VPWR VPWR net75 sky130_fd_sc_hd__dlygate4sd3_1
XFILLER_29_57 VGND VGND VPWR VPWR sky130_fd_sc_hd__decap_3
XPHY_EDGE_ROW_7_Left_54 VGND VGND VPWR VPWR sky130_fd_sc_hd__decap_3
XFILLER_3_254 VPWR VGND VPWR VGND sky130_ef_sc_hd__decap_12
X_856_ clknet_3_1__leaf_clk _070_ _004_ VGND VGND VPWR VPWR len_cnt\[2\] sky130_fd_sc_hd__dfrtp_1
X_787_ _420_ _421_ _426_ net32 VGND VGND VPWR VPWR _000_ sky130_fd_sc_hd__o31a_1
XFILLER_19_100 VGND VGND VPWR VPWR sky130_fd_sc_hd__decap_4
XFILLER_19_111 VGND VGND VPWR VPWR sky130_fd_sc_hd__fill_1
XFILLER_19_155 VGND VGND VPWR VPWR sky130_fd_sc_hd__decap_3
XFILLER_42_180 VGND VGND VPWR VPWR sky130_fd_sc_hd__fill_1
XFILLER_15_15 VPWR VGND VPWR VGND sky130_ef_sc_hd__decap_12
XFILLER_25_125 VPWR VGND VPWR VGND sky130_ef_sc_hd__decap_12
XFILLER_25_169 VPWR VGND VPWR VGND sky130_ef_sc_hd__decap_12
XFILLER_31_14 VPWR VGND VPWR VGND sky130_ef_sc_hd__decap_12
Xoutput25 net25 VGND VGND VPWR VPWR frame_len[4] sky130_fd_sc_hd__buf_2
Xoutput14 net14 VGND VGND VPWR VPWR fcs_valid sky130_fd_sc_hd__buf_2
XFILLER_31_69 VGND VGND VPWR VPWR sky130_fd_sc_hd__fill_2
X_710_ net64 _380_ net31 VGND VGND VPWR VPWR _098_ sky130_fd_sc_hd__mux2_1
X_572_ _152_ _171_ VGND VGND VPWR VPWR _260_ sky130_fd_sc_hd__xnor2_1
X_641_ _318_ _319_ _321_ VGND VGND VPWR VPWR _323_ sky130_fd_sc_hd__and3_1
X_908_ clknet_3_7__leaf_clk _120_ _056_ VGND VGND VPWR VPWR crc_reg\[20\] sky130_fd_sc_hd__dfstp_1
X_839_ net48 VGND VGND VPWR VPWR _053_ sky130_fd_sc_hd__inv_2
XTAP_TAPCELL_ROW_17_175 VGND VPWR sky130_fd_sc_hd__tapvpwrvgnd_1
XFILLER_7_82 VPWR VGND VPWR VGND sky130_ef_sc_hd__decap_12
XFILLER_44_253 VPWR VGND VPWR VGND sky130_ef_sc_hd__decap_12
X_624_ crc_reg\[24\] _188_ VGND VGND VPWR VPWR _307_ sky130_fd_sc_hd__xnor2_2
X_555_ net7 _161_ VGND VGND VPWR VPWR _245_ sky130_fd_sc_hd__xnor2_1
XFILLER_8_121 VPWR VGND VPWR VGND sky130_ef_sc_hd__decap_12
XFILLER_12_194 VGND VGND VPWR VPWR sky130_fd_sc_hd__fill_2
X_486_ _183_ _184_ VGND VGND VPWR VPWR _185_ sky130_fd_sc_hd__xor2_1
XFILLER_12_27 VGND VGND VPWR VPWR sky130_fd_sc_hd__fill_1
XTAP_TAPCELL_ROW_5_124 VGND VPWR sky130_fd_sc_hd__tapvpwrvgnd_1
XFILLER_26_253 VPWR VGND VPWR VGND sky130_ef_sc_hd__decap_12
XTAP_TAPCELL_ROW_28_226 VGND VPWR sky130_fd_sc_hd__tapvpwrvgnd_1
XFILLER_41_223 VGND VGND VPWR VPWR sky130_fd_sc_hd__fill_1
XTAP_TAPCELL_ROW_11_148 VGND VPWR sky130_fd_sc_hd__tapvpwrvgnd_1
XPHY_EDGE_ROW_36_Left_83 VGND VGND VPWR VPWR sky130_fd_sc_hd__decap_3
X_607_ net36 _159_ VGND VGND VPWR VPWR _292_ sky130_fd_sc_hd__nand2_1
X_538_ net33 _227_ _228_ VGND VGND VPWR VPWR _230_ sky130_fd_sc_hd__nor3_1
XFILLER_17_242 VGND VGND VPWR VPWR sky130_fd_sc_hd__decap_8
XPHY_EDGE_ROW_20_Left_67 VGND VGND VPWR VPWR sky130_fd_sc_hd__decap_3
XFILLER_27_90 VPWR VGND VPWR VGND sky130_ef_sc_hd__decap_12
X_469_ net33 _168_ VGND VGND VPWR VPWR _169_ sky130_fd_sc_hd__nand2_1
XFILLER_23_15 VPWR VGND VPWR VGND sky130_ef_sc_hd__decap_12
XFILLER_23_223 VGND VGND VPWR VPWR sky130_fd_sc_hd__fill_1
XFILLER_9_39 VPWR VGND VPWR VGND sky130_ef_sc_hd__decap_12
Xfanout60 net61 VGND VGND VPWR VPWR net60 sky130_fd_sc_hd__buf_2
XTAP_TAPCELL_ROW_0_95 VGND VPWR sky130_fd_sc_hd__tapvpwrvgnd_1
XFILLER_18_15 VPWR VGND VPWR VGND sky130_ef_sc_hd__decap_12
Xclkload2 clknet_3_3__leaf_clk VGND VGND VPWR VPWR clkload2/X sky130_fd_sc_hd__clkbuf_8
XFILLER_46_167 VGND VGND VPWR VPWR sky130_fd_sc_hd__fill_1
X_872_ clknet_3_4__leaf_clk _084_ _020_ VGND VGND VPWR VPWR net15 sky130_fd_sc_hd__dfrtp_1
XFILLER_27_3 VPWR VGND VPWR VGND sky130_ef_sc_hd__decap_12
XFILLER_37_167 VGND VGND VPWR VPWR sky130_fd_sc_hd__fill_1
XPHY_EDGE_ROW_23_Left_70 VGND VGND VPWR VPWR sky130_fd_sc_hd__decap_3
XFILLER_20_27 VGND VGND VPWR VPWR sky130_fd_sc_hd__fill_1
Xhold25 len_cnt\[8\] VGND VGND VPWR VPWR net87 sky130_fd_sc_hd__dlygate4sd3_1
Xhold14 net23 VGND VGND VPWR VPWR net76 sky130_fd_sc_hd__dlygate4sd3_1
XFILLER_45_57 VPWR VGND VPWR VGND sky130_ef_sc_hd__decap_12
XFILLER_43_126 VGND VGND VPWR VPWR sky130_fd_sc_hd__decap_6
XFILLER_3_266 VPWR VGND VPWR VGND sky130_ef_sc_hd__decap_12
XFILLER_3_222 VGND VGND VPWR VPWR sky130_fd_sc_hd__fill_2
X_855_ clknet_3_1__leaf_clk _069_ _003_ VGND VGND VPWR VPWR len_cnt\[1\] sky130_fd_sc_hd__dfrtp_1
X_786_ _422_ _423_ _424_ _425_ VGND VGND VPWR VPWR _426_ sky130_fd_sc_hd__nand4b_1
XFILLER_34_137 VGND VGND VPWR VPWR sky130_fd_sc_hd__decap_3
XFILLER_33_181 VPWR VGND VPWR VGND sky130_ef_sc_hd__decap_12
XFILLER_15_27 VPWR VGND VPWR VGND sky130_ef_sc_hd__decap_12
XFILLER_25_137 VPWR VGND VPWR VGND sky130_ef_sc_hd__decap_12
XFILLER_31_26 VGND VGND VPWR VPWR sky130_fd_sc_hd__decap_3
XPHY_EDGE_ROW_1_Right_1 VGND VGND VPWR VPWR sky130_fd_sc_hd__decap_3
XFILLER_0_225 VPWR VGND VPWR VGND sky130_ef_sc_hd__decap_12
Xoutput26 net26 VGND VGND VPWR VPWR frame_len[5] sky130_fd_sc_hd__buf_2
Xoutput15 net15 VGND VGND VPWR VPWR frame_len[0] sky130_fd_sc_hd__buf_2
XFILLER_0_203 VGND VGND VPWR VPWR sky130_fd_sc_hd__decap_8
X_571_ net33 _257_ VGND VGND VPWR VPWR _259_ sky130_fd_sc_hd__or2_1
X_640_ _318_ _319_ _321_ VGND VGND VPWR VPWR _322_ sky130_fd_sc_hd__a21oi_1
X_907_ clknet_3_1__leaf_clk _119_ _055_ VGND VGND VPWR VPWR crc_reg\[19\] sky130_fd_sc_hd__dfstp_1
X_838_ net48 VGND VGND VPWR VPWR _052_ sky130_fd_sc_hd__inv_2
XTAP_TAPCELL_ROW_17_176 VGND VPWR sky130_fd_sc_hd__tapvpwrvgnd_1
X_769_ _261_ _262_ _268_ _269_ VGND VGND VPWR VPWR _409_ sky130_fd_sc_hd__o22a_1
XFILLER_15_181 VGND VGND VPWR VPWR sky130_fd_sc_hd__fill_1
XFILLER_30_195 VGND VGND VPWR VPWR sky130_fd_sc_hd__fill_1
XFILLER_7_94 VGND VGND VPWR VPWR sky130_fd_sc_hd__decap_4
XFILLER_26_15 VPWR VGND VPWR VGND sky130_ef_sc_hd__decap_12
XFILLER_26_37 VGND VGND VPWR VPWR sky130_fd_sc_hd__fill_2
XFILLER_44_265 VPWR VGND VPWR VGND sky130_ef_sc_hd__decap_12
X_554_ _159_ _242_ VGND VGND VPWR VPWR _244_ sky130_fd_sc_hd__or2_1
X_623_ net54 crc_reg\[10\] VGND VGND VPWR VPWR _306_ sky130_fd_sc_hd__or2_1
X_485_ net8 net2 VGND VGND VPWR VPWR _184_ sky130_fd_sc_hd__xnor2_4
XFILLER_8_133 VGND VGND VPWR VPWR sky130_fd_sc_hd__decap_6
XTAP_TAPCELL_ROW_36_260 VGND VPWR sky130_fd_sc_hd__tapvpwrvgnd_1
XFILLER_26_221 VPWR VGND VPWR VGND sky130_ef_sc_hd__decap_12
XFILLER_26_265 VPWR VGND VPWR VGND sky130_ef_sc_hd__decap_12
XTAP_TAPCELL_ROW_28_227 VGND VPWR sky130_fd_sc_hd__tapvpwrvgnd_1
XTAP_TAPCELL_ROW_11_149 VGND VPWR sky130_fd_sc_hd__tapvpwrvgnd_1
X_537_ _227_ _228_ net33 VGND VGND VPWR VPWR _229_ sky130_fd_sc_hd__o21a_1
X_468_ _166_ _167_ VGND VGND VPWR VPWR _168_ sky130_fd_sc_hd__xnor2_1
X_606_ net36 _287_ VGND VGND VPWR VPWR _291_ sky130_fd_sc_hd__nand2_1
XFILLER_23_27 VPWR VGND VPWR VGND sky130_ef_sc_hd__decap_12
Xfanout50 net12 VGND VGND VPWR VPWR net50 sky130_fd_sc_hd__buf_2
Xfanout61 net62 VGND VGND VPWR VPWR net61 sky130_fd_sc_hd__clkbuf_4
XTAP_TAPCELL_ROW_0_96 VGND VPWR sky130_fd_sc_hd__tapvpwrvgnd_1
Xclkbuf_3_7__f_clk clknet_0_clk VGND VGND VPWR VPWR clknet_3_7__leaf_clk sky130_fd_sc_hd__clkbuf_16
XFILLER_20_249 VGND VGND VPWR VPWR sky130_fd_sc_hd__decap_3
XTAP_TAPCELL_ROW_30_233 VGND VPWR sky130_fd_sc_hd__tapvpwrvgnd_1
XFILLER_18_27 VGND VGND VPWR VPWR sky130_fd_sc_hd__fill_1
XFILLER_11_205 VPWR VGND VPWR VGND sky130_ef_sc_hd__decap_12
XFILLER_34_15 VPWR VGND VPWR VGND sky130_ef_sc_hd__decap_12
Xclkload3 clknet_3_4__leaf_clk VGND VGND VPWR VPWR clkload3/Y sky130_fd_sc_hd__inv_4
X_871_ clknet_3_3__leaf_clk _000_ _019_ VGND VGND VPWR VPWR net13 sky130_fd_sc_hd__dfrtp_1
XFILLER_46_113 VPWR VGND VPWR VGND sky130_ef_sc_hd__decap_12
XFILLER_40_80 VGND VGND VPWR VPWR sky130_fd_sc_hd__decap_4
XFILLER_6_253 VPWR VGND VPWR VGND sky130_ef_sc_hd__decap_12
XFILLER_37_113 VGND VGND VPWR VPWR sky130_fd_sc_hd__decap_4
XFILLER_29_15 VPWR VGND VPWR VGND sky130_ef_sc_hd__decap_12
Xhold26 crc_reg\[17\] VGND VGND VPWR VPWR net88 sky130_fd_sc_hd__dlygate4sd3_1
Xhold15 net22 VGND VGND VPWR VPWR net77 sky130_fd_sc_hd__dlygate4sd3_1
XFILLER_45_69 VPWR VGND VPWR VGND sky130_ef_sc_hd__decap_12
XFILLER_36_190 VGND VGND VPWR VPWR sky130_fd_sc_hd__fill_2
X_854_ clknet_3_1__leaf_clk _068_ _002_ VGND VGND VPWR VPWR len_cnt\[0\] sky130_fd_sc_hd__dfrtp_1
XFILLER_10_83 VGND VGND VPWR VPWR sky130_fd_sc_hd__fill_1
XFILLER_19_113 VPWR VGND VPWR VGND sky130_ef_sc_hd__decap_12
X_785_ _304_ _305_ _315_ _316_ VGND VGND VPWR VPWR _425_ sky130_fd_sc_hd__o22a_1
XFILLER_19_81 VPWR VGND VPWR VGND sky130_ef_sc_hd__decap_12
XFILLER_34_105 VPWR VGND VPWR VGND sky130_ef_sc_hd__decap_12
XFILLER_42_193 VGND VGND VPWR VPWR sky130_fd_sc_hd__decap_3
XFILLER_33_193 VPWR VGND VPWR VGND sky130_ef_sc_hd__decap_12
XFILLER_15_39 VPWR VGND VPWR VGND sky130_ef_sc_hd__decap_12
XFILLER_25_149 VPWR VGND VPWR VGND sky130_ef_sc_hd__decap_12
XFILLER_0_237 VGND VGND VPWR VPWR sky130_fd_sc_hd__decap_8
Xoutput27 net27 VGND VGND VPWR VPWR frame_len[6] sky130_fd_sc_hd__buf_2
Xoutput16 net16 VGND VGND VPWR VPWR frame_len[10] sky130_fd_sc_hd__buf_2
X_570_ net33 _257_ VGND VGND VPWR VPWR _258_ sky130_fd_sc_hd__nand2_1
XFILLER_24_182 VGND VGND VPWR VPWR sky130_fd_sc_hd__fill_1
XFILLER_21_60 VGND VGND VPWR VPWR sky130_fd_sc_hd__decap_6
XFILLER_21_71 VGND VGND VPWR VPWR sky130_fd_sc_hd__fill_1
X_768_ net51 len_cnt\[0\] _407_ VGND VGND VPWR VPWR _068_ sky130_fd_sc_hd__o21a_1
X_906_ clknet_3_4__leaf_clk _118_ _054_ VGND VGND VPWR VPWR crc_reg\[18\] sky130_fd_sc_hd__dfstp_1
X_837_ net44 VGND VGND VPWR VPWR _051_ sky130_fd_sc_hd__inv_2
X_699_ len_cnt\[9\] len_cnt\[8\] len_cnt\[7\] _369_ VGND VGND VPWR VPWR _371_ sky130_fd_sc_hd__and4_1
XTAP_TAPCELL_ROW_17_177 VGND VPWR sky130_fd_sc_hd__tapvpwrvgnd_1
Xclkbuf_0_clk clk VGND VGND VPWR VPWR clknet_0_clk sky130_fd_sc_hd__clkbuf_16
XFILLER_30_130 VGND VGND VPWR VPWR sky130_fd_sc_hd__decap_8
XFILLER_30_141 VGND VGND VPWR VPWR sky130_fd_sc_hd__fill_1
XPHY_EDGE_ROW_15_Right_15 VGND VGND VPWR VPWR sky130_fd_sc_hd__decap_3
XPHY_EDGE_ROW_24_Right_24 VGND VGND VPWR VPWR sky130_fd_sc_hd__decap_3
XFILLER_26_27 VGND VGND VPWR VPWR sky130_fd_sc_hd__fill_1
XFILLER_42_15 VPWR VGND VPWR VGND sky130_ef_sc_hd__decap_12
XPHY_EDGE_ROW_33_Right_33 VGND VGND VPWR VPWR sky130_fd_sc_hd__decap_3
XTAP_TAPCELL_ROW_8_134 VGND VPWR sky130_fd_sc_hd__tapvpwrvgnd_1
X_622_ net41 _304_ _305_ _298_ VGND VGND VPWR VPWR _111_ sky130_fd_sc_hd__o31a_1
XFILLER_44_277 VGND VGND VPWR VPWR sky130_fd_sc_hd__fill_1
XPHY_EDGE_ROW_42_Right_42 VGND VGND VPWR VPWR sky130_fd_sc_hd__decap_3
X_553_ _159_ _242_ VGND VGND VPWR VPWR _243_ sky130_fd_sc_hd__nand2_1
X_484_ net5 net4 VGND VGND VPWR VPWR _183_ sky130_fd_sc_hd__xnor2_4
XFILLER_12_141 VPWR VGND VPWR VGND sky130_ef_sc_hd__decap_12
XFILLER_35_277 VGND VGND VPWR VPWR sky130_fd_sc_hd__fill_1
XFILLER_12_29 VGND VGND VPWR VPWR sky130_fd_sc_hd__fill_1
XFILLER_37_15 VPWR VGND VPWR VGND sky130_ef_sc_hd__decap_12
XFILLER_41_236 VPWR VGND VPWR VGND sky130_ef_sc_hd__decap_12
XFILLER_41_225 VGND VGND VPWR VPWR sky130_fd_sc_hd__fill_2
XFILLER_41_203 VGND VGND VPWR VPWR sky130_fd_sc_hd__decap_3
XTAP_TAPCELL_ROW_36_261 VGND VPWR sky130_fd_sc_hd__tapvpwrvgnd_1
XFILLER_26_233 VPWR VGND VPWR VGND sky130_ef_sc_hd__decap_12
XFILLER_26_277 VGND VGND VPWR VPWR sky130_fd_sc_hd__fill_1
XTAP_TAPCELL_ROW_28_228 VGND VPWR sky130_fd_sc_hd__tapvpwrvgnd_1
X_605_ _287_ _289_ VGND VGND VPWR VPWR _290_ sky130_fd_sc_hd__xnor2_1
X_536_ crc_reg\[27\] crc_reg\[11\] VGND VGND VPWR VPWR _228_ sky130_fd_sc_hd__and2_1
X_467_ crc_reg\[25\] crc_reg\[19\] VGND VGND VPWR VPWR _167_ sky130_fd_sc_hd__xnor2_1
XFILLER_32_225 VPWR VGND VPWR VGND sky130_ef_sc_hd__decap_12
XFILLER_4_41 VGND VGND VPWR VPWR sky130_fd_sc_hd__decap_6
XTAP_TAPCELL_ROW_2_107 VGND VPWR sky130_fd_sc_hd__tapvpwrvgnd_1
XFILLER_23_225 VGND VGND VPWR VPWR sky130_fd_sc_hd__decap_8
XFILLER_23_39 VGND VGND VPWR VPWR sky130_fd_sc_hd__decap_8
XFILLER_2_129 VGND VGND VPWR VPWR sky130_fd_sc_hd__fill_2
Xfanout40 net41 VGND VGND VPWR VPWR net40 sky130_fd_sc_hd__dlymetal6s2s_1
Xfanout62 net10 VGND VGND VPWR VPWR net62 sky130_fd_sc_hd__clkbuf_4
Xfanout51 net52 VGND VGND VPWR VPWR net51 sky130_fd_sc_hd__clkbuf_4
XTAP_TAPCELL_ROW_0_97 VGND VPWR sky130_fd_sc_hd__tapvpwrvgnd_1
X_519_ net39 _213_ _214_ VGND VGND VPWR VPWR _215_ sky130_fd_sc_hd__or3_1
XTAP_TAPCELL_ROW_30_234 VGND VPWR sky130_fd_sc_hd__tapvpwrvgnd_1
XFILLER_11_217 VGND VGND VPWR VPWR sky130_fd_sc_hd__fill_2
XFILLER_34_27 VGND VGND VPWR VPWR sky130_fd_sc_hd__fill_1
Xclkload4 clknet_3_5__leaf_clk VGND VGND VPWR VPWR clkload4/Y sky130_fd_sc_hd__bufinv_16
X_870_ clknet_3_3__leaf_clk _001_ _018_ VGND VGND VPWR VPWR net14 sky130_fd_sc_hd__dfrtp_1
XFILLER_46_125 VGND VGND VPWR VPWR sky130_fd_sc_hd__decap_8
XFILLER_6_265 VPWR VGND VPWR VGND sky130_ef_sc_hd__decap_12
XFILLER_37_169 VGND VGND VPWR VPWR sky130_fd_sc_hd__decap_4
XFILLER_20_29 VGND VGND VPWR VPWR sky130_fd_sc_hd__decap_6
Xhold16 net15 VGND VGND VPWR VPWR net78 sky130_fd_sc_hd__dlygate4sd3_1
Xhold27 crc_reg\[7\] VGND VGND VPWR VPWR net89 sky130_fd_sc_hd__dlygate4sd3_1
XFILLER_29_27 VPWR VGND VPWR VGND sky130_ef_sc_hd__decap_12
XFILLER_45_15 VPWR VGND VPWR VGND sky130_ef_sc_hd__decap_12
X_853_ net48 VGND VGND VPWR VPWR _067_ sky130_fd_sc_hd__inv_2
X_784_ _283_ _284_ _296_ _297_ VGND VGND VPWR VPWR _424_ sky130_fd_sc_hd__o22a_1
XFILLER_19_125 VGND VGND VPWR VPWR sky130_fd_sc_hd__decap_3
XFILLER_19_93 VGND VGND VPWR VPWR sky130_fd_sc_hd__decap_4
XFILLER_19_169 VPWR VGND VPWR VGND sky130_ef_sc_hd__decap_12
XFILLER_34_117 VPWR VGND VPWR VGND sky130_ef_sc_hd__decap_12
XFILLER_32_3 VPWR VGND VPWR VGND sky130_ef_sc_hd__decap_12
XFILLER_40_109 VPWR VGND VPWR VGND sky130_ef_sc_hd__decap_12
XFILLER_33_161 VGND VGND VPWR VPWR sky130_fd_sc_hd__decap_6
Xoutput28 net28 VGND VGND VPWR VPWR frame_len[7] sky130_fd_sc_hd__buf_2
Xoutput17 net17 VGND VGND VPWR VPWR frame_len[11] sky130_fd_sc_hd__buf_2
X_905_ clknet_3_5__leaf_clk _117_ _053_ VGND VGND VPWR VPWR crc_reg\[17\] sky130_fd_sc_hd__dfstp_1
X_767_ len_cnt\[1\] _406_ net51 VGND VGND VPWR VPWR _069_ sky130_fd_sc_hd__mux2_1
X_836_ net48 VGND VGND VPWR VPWR _050_ sky130_fd_sc_hd__inv_2
X_698_ len_cnt\[8\] len_cnt\[7\] _369_ VGND VGND VPWR VPWR _370_ sky130_fd_sc_hd__and3_1
XTAP_TAPCELL_ROW_17_178 VGND VPWR sky130_fd_sc_hd__tapvpwrvgnd_1
XFILLER_38_253 VPWR VGND VPWR VGND sky130_ef_sc_hd__decap_12
XFILLER_42_27 VGND VGND VPWR VPWR sky130_fd_sc_hd__fill_1
XTAP_TAPCELL_ROW_8_135 VGND VPWR sky130_fd_sc_hd__tapvpwrvgnd_1
X_621_ _302_ _303_ _299_ VGND VGND VPWR VPWR _305_ sky130_fd_sc_hd__a21boi_1
XFILLER_44_245 VGND VGND VPWR VPWR sky130_fd_sc_hd__decap_6
XFILLER_12_153 VGND VGND VPWR VPWR sky130_fd_sc_hd__decap_8
X_483_ _178_ _180_ VGND VGND VPWR VPWR _182_ sky130_fd_sc_hd__or2_1
XFILLER_16_83 VGND VGND VPWR VPWR sky130_fd_sc_hd__fill_1
X_552_ crc_reg\[25\] crc_reg\[9\] VGND VGND VPWR VPWR _242_ sky130_fd_sc_hd__xor2_1
XFILLER_12_164 VPWR VGND VPWR VGND sky130_ef_sc_hd__decap_12
XFILLER_12_186 VGND VGND VPWR VPWR sky130_fd_sc_hd__decap_8
XFILLER_12_197 VPWR VGND VPWR VGND sky130_ef_sc_hd__decap_12
XFILLER_32_82 VGND VGND VPWR VPWR sky130_fd_sc_hd__fill_2
XFILLER_32_93 VGND VGND VPWR VPWR sky130_fd_sc_hd__fill_2
X_819_ net46 VGND VGND VPWR VPWR _033_ sky130_fd_sc_hd__inv_2
XFILLER_12_19 VGND VGND VPWR VPWR sky130_fd_sc_hd__decap_8
XFILLER_37_27 VPWR VGND VPWR VGND sky130_ef_sc_hd__decap_12
XFILLER_41_248 VPWR VGND VPWR VGND sky130_ef_sc_hd__decap_12
XFILLER_41_215 VGND VGND VPWR VPWR sky130_fd_sc_hd__decap_8
XTAP_TAPCELL_ROW_36_262 VGND VPWR sky130_fd_sc_hd__tapvpwrvgnd_1
XFILLER_26_245 VGND VGND VPWR VPWR sky130_fd_sc_hd__decap_6
XFILLER_5_149 VPWR VGND VPWR VGND sky130_ef_sc_hd__decap_12
X_604_ _159_ _288_ VGND VGND VPWR VPWR _289_ sky130_fd_sc_hd__xnor2_1
X_535_ crc_reg\[27\] crc_reg\[11\] VGND VGND VPWR VPWR _227_ sky130_fd_sc_hd__nor2_1
XFILLER_27_82 VGND VGND VPWR VPWR sky130_fd_sc_hd__fill_1
XTAP_TAPCELL_ROW_42_287 VGND VPWR sky130_fd_sc_hd__tapvpwrvgnd_1
X_466_ crc_reg\[29\] crc_reg\[28\] VGND VGND VPWR VPWR _166_ sky130_fd_sc_hd__xnor2_2
XFILLER_32_237 VPWR VGND VPWR VGND sky130_ef_sc_hd__decap_12
XFILLER_4_182 VPWR VGND VPWR VGND sky130_ef_sc_hd__decap_12
XFILLER_4_171 VGND VGND VPWR VPWR sky130_fd_sc_hd__decap_8
XTAP_TAPCELL_ROW_2_108 VGND VPWR sky130_fd_sc_hd__tapvpwrvgnd_1
XFILLER_23_248 VPWR VGND VPWR VGND sky130_ef_sc_hd__decap_12
XFILLER_2_108 VGND VGND VPWR VPWR sky130_fd_sc_hd__fill_1
Xfanout41 _132_ VGND VGND VPWR VPWR net41 sky130_fd_sc_hd__buf_2
XFILLER_13_51 VGND VGND VPWR VPWR sky130_fd_sc_hd__decap_4
XFILLER_14_226 VGND VGND VPWR VPWR sky130_fd_sc_hd__fill_2
Xfanout52 net57 VGND VGND VPWR VPWR net52 sky130_fd_sc_hd__clkbuf_2
XTAP_TAPCELL_ROW_24_210 VGND VPWR sky130_fd_sc_hd__tapvpwrvgnd_1
XTAP_TAPCELL_ROW_0_98 VGND VPWR sky130_fd_sc_hd__tapvpwrvgnd_1
X_518_ net60 _208_ _211_ _212_ VGND VGND VPWR VPWR _214_ sky130_fd_sc_hd__o22a_1
X_449_ _149_ _150_ VGND VGND VPWR VPWR _151_ sky130_fd_sc_hd__xnor2_1
XFILLER_20_229 VPWR VGND VPWR VGND sky130_ef_sc_hd__decap_12
XTAP_TAPCELL_ROW_30_235 VGND VPWR sky130_fd_sc_hd__tapvpwrvgnd_1
XFILLER_18_29 VPWR VGND VPWR VGND sky130_ef_sc_hd__decap_12
Xclkload5 clknet_3_6__leaf_clk VGND VGND VPWR VPWR clkload5/Y sky130_fd_sc_hd__inv_4
XFILLER_10_251 VGND VGND VPWR VPWR sky130_fd_sc_hd__fill_1
XFILLER_6_277 VGND VGND VPWR VPWR sky130_fd_sc_hd__fill_1
XFILLER_37_159 VGND VGND VPWR VPWR sky130_fd_sc_hd__decap_8
XFILLER_1_54 VGND VGND VPWR VPWR sky130_fd_sc_hd__fill_2
Xhold28 crc_reg\[16\] VGND VGND VPWR VPWR net90 sky130_fd_sc_hd__dlygate4sd3_1
Xhold17 len_cnt\[9\] VGND VGND VPWR VPWR net79 sky130_fd_sc_hd__dlygate4sd3_1
XFILLER_29_39 VPWR VGND VPWR VGND sky130_ef_sc_hd__decap_12
XFILLER_45_27 VPWR VGND VPWR VGND sky130_ef_sc_hd__decap_12
XFILLER_28_126 VPWR VGND VPWR VGND sky130_ef_sc_hd__decap_12
XFILLER_3_225 VGND VGND VPWR VPWR sky130_fd_sc_hd__decap_4
XFILLER_3_214 VGND VGND VPWR VPWR sky130_fd_sc_hd__decap_8
XFILLER_10_41 VGND VGND VPWR VPWR sky130_fd_sc_hd__decap_3
XFILLER_10_96 VPWR VGND VPWR VGND sky130_ef_sc_hd__decap_12
X_852_ net49 VGND VGND VPWR VPWR _066_ sky130_fd_sc_hd__inv_2
X_783_ _339_ _340_ _333_ _334_ VGND VGND VPWR VPWR _423_ sky130_fd_sc_hd__o211a_1
XFILLER_42_162 VPWR VGND VPWR VGND sky130_ef_sc_hd__decap_12
XFILLER_34_129 VGND VGND VPWR VPWR sky130_fd_sc_hd__decap_8
XFILLER_25_3 VPWR VGND VPWR VGND sky130_ef_sc_hd__decap_12
XPHY_EDGE_ROW_27_Left_74 VGND VGND VPWR VPWR sky130_fd_sc_hd__decap_3
XPHY_EDGE_ROW_11_Left_58 VGND VGND VPWR VPWR sky130_fd_sc_hd__decap_3
XFILLER_18_192 VGND VGND VPWR VPWR sky130_fd_sc_hd__decap_4
XFILLER_25_107 VGND VGND VPWR VPWR sky130_fd_sc_hd__decap_4
Xoutput18 net18 VGND VGND VPWR VPWR frame_len[12] sky130_fd_sc_hd__buf_2
Xoutput29 net29 VGND VGND VPWR VPWR frame_len[8] sky130_fd_sc_hd__buf_2
XFILLER_0_217 VGND VGND VPWR VPWR sky130_fd_sc_hd__decap_6
XFILLER_24_173 VGND VGND VPWR VPWR sky130_fd_sc_hd__fill_2
X_904_ clknet_3_5__leaf_clk _116_ _052_ VGND VGND VPWR VPWR crc_reg\[16\] sky130_fd_sc_hd__dfstp_1
XFILLER_46_81 VGND VGND VPWR VPWR sky130_fd_sc_hd__decap_3
X_835_ net49 VGND VGND VPWR VPWR _049_ sky130_fd_sc_hd__inv_2
X_766_ net85 _404_ net51 VGND VGND VPWR VPWR _070_ sky130_fd_sc_hd__mux2_1
X_697_ len_cnt\[6\] len_cnt\[5\] len_cnt\[4\] _367_ VGND VGND VPWR VPWR _369_ sky130_fd_sc_hd__and4_1
XFILLER_15_162 VGND VGND VPWR VPWR sky130_fd_sc_hd__decap_6
XFILLER_38_265 VPWR VGND VPWR VGND sky130_ef_sc_hd__decap_12
XPHY_EDGE_ROW_5_Right_5 VGND VGND VPWR VPWR sky130_fd_sc_hd__decap_3
XFILLER_21_121 VGND VGND VPWR VPWR sky130_fd_sc_hd__decap_3
XFILLER_26_29 VGND VGND VPWR VPWR sky130_fd_sc_hd__decap_8
XFILLER_21_176 VPWR VGND VPWR VGND sky130_ef_sc_hd__decap_12
XTAP_TAPCELL_ROW_8_136 VGND VPWR sky130_fd_sc_hd__tapvpwrvgnd_1
X_551_ net38 _240_ _241_ _234_ VGND VGND VPWR VPWR _118_ sky130_fd_sc_hd__o31a_1
X_620_ _299_ _302_ _303_ VGND VGND VPWR VPWR _304_ sky130_fd_sc_hd__and3b_1
XFILLER_29_221 VGND VGND VPWR VPWR sky130_fd_sc_hd__decap_3
XFILLER_12_176 VGND VGND VPWR VPWR sky130_fd_sc_hd__fill_2
X_482_ _178_ _180_ VGND VGND VPWR VPWR _181_ sky130_fd_sc_hd__nand2_1
X_818_ net46 VGND VGND VPWR VPWR _032_ sky130_fd_sc_hd__inv_2
X_749_ net77 _406_ net31 VGND VGND VPWR VPWR _085_ sky130_fd_sc_hd__mux2_1
XTAP_TAPCELL_ROW_13_160 VGND VPWR sky130_fd_sc_hd__tapvpwrvgnd_1
XFILLER_37_39 VPWR VGND VPWR VGND sky130_ef_sc_hd__decap_12
XFILLER_26_213 VGND VGND VPWR VPWR sky130_fd_sc_hd__fill_1
XTAP_TAPCELL_ROW_36_263 VGND VPWR sky130_fd_sc_hd__tapvpwrvgnd_1
XPHY_EDGE_ROW_14_Left_61 VGND VGND VPWR VPWR sky130_fd_sc_hd__decap_3
XFILLER_5_128 VGND VGND VPWR VPWR sky130_fd_sc_hd__fill_1
X_465_ net39 _163_ _164_ _165_ VGND VGND VPWR VPWR _128_ sky130_fd_sc_hd__o31ai_1
X_534_ crc_reg\[20\] _226_ net56 VGND VGND VPWR VPWR _120_ sky130_fd_sc_hd__mux2_1
X_603_ crc_reg\[28\] crc_reg\[4\] VGND VGND VPWR VPWR _288_ sky130_fd_sc_hd__xor2_1
XFILLER_27_50 VGND VGND VPWR VPWR sky130_fd_sc_hd__decap_3
XFILLER_27_72 VGND VGND VPWR VPWR sky130_fd_sc_hd__fill_1
XFILLER_32_216 VGND VGND VPWR VPWR sky130_fd_sc_hd__fill_2
XTAP_TAPCELL_ROW_42_288 VGND VPWR sky130_fd_sc_hd__tapvpwrvgnd_1
XFILLER_32_249 VGND VGND VPWR VPWR sky130_fd_sc_hd__decap_3
XFILLER_4_194 VGND VGND VPWR VPWR sky130_fd_sc_hd__fill_2
XFILLER_4_98 VGND VGND VPWR VPWR sky130_fd_sc_hd__fill_1
XTAP_TAPCELL_ROW_2_109 VGND VPWR sky130_fd_sc_hd__tapvpwrvgnd_1
Xfanout42 net44 VGND VGND VPWR VPWR net42 sky130_fd_sc_hd__buf_4
Xfanout31 _364_ VGND VGND VPWR VPWR net31 sky130_fd_sc_hd__clkbuf_4
Xfanout53 net57 VGND VGND VPWR VPWR net53 sky130_fd_sc_hd__clkbuf_4
XTAP_TAPCELL_ROW_0_99 VGND VPWR sky130_fd_sc_hd__tapvpwrvgnd_1
X_448_ crc_reg\[27\] crc_reg\[21\] VGND VGND VPWR VPWR _150_ sky130_fd_sc_hd__xor2_1
X_517_ net60 _208_ _211_ _212_ VGND VGND VPWR VPWR _213_ sky130_fd_sc_hd__nor4_1
XTAP_TAPCELL_ROW_30_236 VGND VPWR sky130_fd_sc_hd__tapvpwrvgnd_1
XPHY_EDGE_ROW_41_Left_88 VGND VGND VPWR VPWR sky130_fd_sc_hd__decap_3
Xclkload6 clknet_3_7__leaf_clk VGND VGND VPWR VPWR clkload6/Y sky130_fd_sc_hd__clkinv_2
XFILLER_34_29 VPWR VGND VPWR VGND sky130_ef_sc_hd__decap_12
XFILLER_46_149 VPWR VGND VPWR VGND sky130_ef_sc_hd__decap_12
XFILLER_39_190 VGND VGND VPWR VPWR sky130_fd_sc_hd__decap_8
XFILLER_6_234 VPWR VGND VPWR VGND sky130_ef_sc_hd__decap_12
XFILLER_24_73 VGND VGND VPWR VPWR sky130_fd_sc_hd__fill_1
XFILLER_37_149 VGND VGND VPWR VPWR sky130_fd_sc_hd__decap_3
XFILLER_37_105 VGND VGND VPWR VPWR sky130_fd_sc_hd__decap_6
Xhold18 len_cnt\[3\] VGND VGND VPWR VPWR net80 sky130_fd_sc_hd__dlygate4sd3_1
XFILLER_28_138 VGND VGND VPWR VPWR sky130_fd_sc_hd__fill_2
XFILLER_45_39 VPWR VGND VPWR VGND sky130_ef_sc_hd__decap_12
X_851_ net49 VGND VGND VPWR VPWR _065_ sky130_fd_sc_hd__inv_2
X_782_ _327_ _328_ _322_ _323_ VGND VGND VPWR VPWR _422_ sky130_fd_sc_hd__a211o_1
XFILLER_42_174 VGND VGND VPWR VPWR sky130_fd_sc_hd__decap_6
XFILLER_18_3 VPWR VGND VPWR VGND sky130_ef_sc_hd__decap_12
XFILLER_18_171 VPWR VGND VPWR VGND sky130_ef_sc_hd__decap_12
Xoutput19 net19 VGND VGND VPWR VPWR frame_len[13] sky130_fd_sc_hd__buf_2
XFILLER_16_108 VPWR VGND VPWR VGND sky130_ef_sc_hd__decap_12
XPHY_EDGE_ROW_44_Left_91 VGND VGND VPWR VPWR sky130_fd_sc_hd__decap_3
XFILLER_24_141 VPWR VGND VPWR VGND sky130_ef_sc_hd__decap_12
XFILLER_21_85 VGND VGND VPWR VPWR sky130_fd_sc_hd__fill_1
X_834_ net49 VGND VGND VPWR VPWR _048_ sky130_fd_sc_hd__inv_2
X_903_ clknet_3_4__leaf_clk _115_ _051_ VGND VGND VPWR VPWR crc_reg\[15\] sky130_fd_sc_hd__dfstp_1
X_696_ len_cnt\[5\] len_cnt\[4\] _367_ VGND VGND VPWR VPWR _368_ sky130_fd_sc_hd__and3_1
X_765_ net80 _402_ net51 VGND VGND VPWR VPWR _071_ sky130_fd_sc_hd__mux2_1
XFILLER_30_155 VPWR VGND VPWR VGND sky130_ef_sc_hd__decap_12
XFILLER_38_277 VGND VGND VPWR VPWR sky130_fd_sc_hd__fill_1
XFILLER_42_29 VPWR VGND VPWR VGND sky130_ef_sc_hd__decap_12
XFILLER_21_111 VGND VGND VPWR VPWR sky130_fd_sc_hd__fill_1
XFILLER_21_188 VPWR VGND VPWR VGND sky130_ef_sc_hd__decap_12
XTAP_TAPCELL_ROW_8_137 VGND VPWR sky130_fd_sc_hd__tapvpwrvgnd_1
XFILLER_29_200 VGND VGND VPWR VPWR sky130_fd_sc_hd__decap_6
X_481_ crc_reg\[18\] _179_ VGND VGND VPWR VPWR _180_ sky130_fd_sc_hd__xnor2_1
XFILLER_16_41 VGND VGND VPWR VPWR sky130_fd_sc_hd__fill_1
X_550_ net34 _236_ _237_ _239_ VGND VGND VPWR VPWR _241_ sky130_fd_sc_hd__a31oi_1
XFILLER_8_148 VGND VGND VPWR VPWR sky130_fd_sc_hd__fill_2
XPHY_EDGE_ROW_11_Right_11 VGND VGND VPWR VPWR sky130_fd_sc_hd__decap_3
XFILLER_12_111 VGND VGND VPWR VPWR sky130_fd_sc_hd__decap_4
XFILLER_16_85 VGND VGND VPWR VPWR sky130_fd_sc_hd__decap_3
XPHY_EDGE_ROW_20_Right_20 VGND VGND VPWR VPWR sky130_fd_sc_hd__decap_3
X_817_ net46 VGND VGND VPWR VPWR _031_ sky130_fd_sc_hd__inv_2
XFILLER_35_247 VPWR VGND VPWR VGND sky130_ef_sc_hd__decap_12
XFILLER_35_225 VPWR VGND VPWR VGND sky130_ef_sc_hd__decap_12
X_679_ _278_ _354_ VGND VGND VPWR VPWR _355_ sky130_fd_sc_hd__xnor2_1
X_748_ len_cnt\[1\] len_cnt\[0\] _405_ VGND VGND VPWR VPWR _406_ sky130_fd_sc_hd__o21a_1
XTAP_TAPCELL_ROW_36_264 VGND VPWR sky130_fd_sc_hd__tapvpwrvgnd_1
XFILLER_17_203 VGND VGND VPWR VPWR sky130_fd_sc_hd__decap_8
X_602_ crc_reg\[26\] _207_ VGND VGND VPWR VPWR _287_ sky130_fd_sc_hd__xor2_1
X_464_ net40 crc_reg\[28\] VGND VGND VPWR VPWR _165_ sky130_fd_sc_hd__nand2_1
X_533_ net4 _225_ VGND VGND VPWR VPWR _226_ sky130_fd_sc_hd__xnor2_1
XTAP_TAPCELL_ROW_27_220 VGND VPWR sky130_fd_sc_hd__tapvpwrvgnd_1
XFILLER_32_206 VGND VGND VPWR VPWR sky130_fd_sc_hd__decap_3
XTAP_TAPCELL_ROW_42_289 VGND VPWR sky130_fd_sc_hd__tapvpwrvgnd_1
Xclkbuf_3_2__f_clk clknet_0_clk VGND VGND VPWR VPWR clknet_3_2__leaf_clk sky130_fd_sc_hd__clkbuf_16
XFILLER_23_217 VGND VGND VPWR VPWR sky130_fd_sc_hd__decap_6
XFILLER_31_261 VPWR VGND VPWR VGND sky130_ef_sc_hd__decap_12
Xfanout32 _364_ VGND VGND VPWR VPWR net32 sky130_fd_sc_hd__buf_2
Xfanout43 net44 VGND VGND VPWR VPWR net43 sky130_fd_sc_hd__clkbuf_4
Xfanout54 net57 VGND VGND VPWR VPWR net54 sky130_fd_sc_hd__clkbuf_2
XFILLER_22_250 VGND VGND VPWR VPWR sky130_fd_sc_hd__fill_2
XFILLER_1_165 VGND VGND VPWR VPWR sky130_fd_sc_hd__decap_3
XFILLER_38_83 VGND VGND VPWR VPWR sky130_fd_sc_hd__fill_1
X_447_ net33 crc_reg\[30\] VGND VGND VPWR VPWR _149_ sky130_fd_sc_hd__xnor2_2
XFILLER_9_221 VGND VGND VPWR VPWR sky130_fd_sc_hd__decap_3
X_516_ _184_ _209_ _210_ VGND VGND VPWR VPWR _212_ sky130_fd_sc_hd__and3_1
XTAP_TAPCELL_ROW_30_237 VGND VPWR sky130_fd_sc_hd__tapvpwrvgnd_1
XFILLER_24_41 VGND VGND VPWR VPWR sky130_fd_sc_hd__decap_3
XFILLER_24_85 VPWR VGND VPWR VGND sky130_ef_sc_hd__decap_12
XFILLER_6_246 VGND VGND VPWR VPWR sky130_fd_sc_hd__decap_6
XFILLER_10_253 VPWR VGND VPWR VGND sky130_ef_sc_hd__decap_12
XFILLER_37_117 VGND VGND VPWR VPWR sky130_fd_sc_hd__fill_1
XFILLER_1_67 VGND VGND VPWR VPWR sky130_fd_sc_hd__decap_8
Xhold19 len_cnt\[6\] VGND VGND VPWR VPWR net81 sky130_fd_sc_hd__dlygate4sd3_1
XFILLER_3_205 VGND VGND VPWR VPWR sky130_fd_sc_hd__decap_6
X_850_ net49 VGND VGND VPWR VPWR _064_ sky130_fd_sc_hd__inv_2
X_781_ _357_ _346_ _352_ VGND VGND VPWR VPWR _421_ sky130_fd_sc_hd__nand3b_1
XFILLER_42_120 VGND VGND VPWR VPWR sky130_fd_sc_hd__decap_8
XFILLER_27_161 VGND VGND VPWR VPWR sky130_fd_sc_hd__decap_6
XFILLER_42_197 VPWR VGND VPWR VGND sky130_ef_sc_hd__decap_12
XFILLER_35_95 VGND VGND VPWR VPWR sky130_fd_sc_hd__decap_4
XFILLER_18_183 VGND VGND VPWR VPWR sky130_fd_sc_hd__fill_2
XFILLER_24_131 VGND VGND VPWR VPWR sky130_fd_sc_hd__decap_8
XFILLER_24_153 VPWR VGND VPWR VGND sky130_ef_sc_hd__decap_12
XFILLER_24_197 VPWR VGND VPWR VGND sky130_ef_sc_hd__decap_12
X_764_ len_cnt\[4\] _400_ net51 VGND VGND VPWR VPWR _072_ sky130_fd_sc_hd__mux2_1
X_833_ net50 VGND VGND VPWR VPWR _047_ sky130_fd_sc_hd__inv_2
X_902_ clknet_3_4__leaf_clk _114_ _050_ VGND VGND VPWR VPWR crc_reg\[14\] sky130_fd_sc_hd__dfstp_1
X_695_ len_cnt\[3\] len_cnt\[2\] len_cnt\[1\] len_cnt\[0\] VGND VGND VPWR VPWR _367_
+ sky130_fd_sc_hd__and4_1
XFILLER_30_167 VPWR VGND VPWR VGND sky130_ef_sc_hd__decap_12
XFILLER_30_3 VPWR VGND VPWR VGND sky130_ef_sc_hd__decap_12
XTAP_TAPCELL_ROW_16_170 VGND VPWR sky130_fd_sc_hd__tapvpwrvgnd_1
XTAP_TAPCELL_ROW_8_138 VGND VPWR sky130_fd_sc_hd__tapvpwrvgnd_1
X_480_ crc_reg\[30\] crc_reg\[24\] VGND VGND VPWR VPWR _179_ sky130_fd_sc_hd__xnor2_1
XFILLER_32_41 VPWR VGND VPWR VGND sky130_ef_sc_hd__decap_12
XFILLER_32_74 VGND VGND VPWR VPWR sky130_fd_sc_hd__fill_1
XFILLER_32_85 VGND VGND VPWR VPWR sky130_fd_sc_hd__decap_8
XFILLER_35_237 VGND VGND VPWR VPWR sky130_fd_sc_hd__decap_6
XFILLER_35_215 VGND VGND VPWR VPWR sky130_fd_sc_hd__fill_2
X_816_ net45 VGND VGND VPWR VPWR _030_ sky130_fd_sc_hd__inv_2
X_747_ len_cnt\[1\] len_cnt\[0\] net59 VGND VGND VPWR VPWR _405_ sky130_fd_sc_hd__a21oi_1
XFILLER_35_259 VPWR VGND VPWR VGND sky130_ef_sc_hd__decap_12
X_678_ _196_ _353_ VGND VGND VPWR VPWR _354_ sky130_fd_sc_hd__xnor2_1
X_601_ net56 crc_reg\[12\] VGND VGND VPWR VPWR _286_ sky130_fd_sc_hd__or2_1
XFILLER_43_51 VGND VGND VPWR VPWR sky130_fd_sc_hd__fill_2
X_532_ crc_reg\[28\] crc_reg\[12\] _224_ VGND VGND VPWR VPWR _225_ sky130_fd_sc_hd__o21ai_1
X_463_ net35 _160_ _162_ VGND VGND VPWR VPWR _164_ sky130_fd_sc_hd__and3_1
XTAP_TAPCELL_ROW_27_221 VGND VPWR sky130_fd_sc_hd__tapvpwrvgnd_1
XFILLER_43_84 VGND VGND VPWR VPWR sky130_fd_sc_hd__fill_1
XTAP_TAPCELL_ROW_10_143 VGND VPWR sky130_fd_sc_hd__tapvpwrvgnd_1
XFILLER_31_273 VGND VGND VPWR VPWR sky130_fd_sc_hd__decap_4
Xfanout55 net57 VGND VGND VPWR VPWR net55 sky130_fd_sc_hd__buf_2
Xfanout44 net50 VGND VGND VPWR VPWR net44 sky130_fd_sc_hd__buf_2
XFILLER_14_218 VGND VGND VPWR VPWR sky130_fd_sc_hd__decap_8
Xfanout33 crc_reg\[31\] VGND VGND VPWR VPWR net33 sky130_fd_sc_hd__buf_4
XFILLER_8_3 VPWR VGND VPWR VGND sky130_ef_sc_hd__decap_12
XFILLER_1_111 VGND VGND VPWR VPWR sky130_fd_sc_hd__fill_1
XFILLER_1_155 VGND VGND VPWR VPWR sky130_fd_sc_hd__fill_1
X_515_ _209_ _210_ _184_ VGND VGND VPWR VPWR _211_ sky130_fd_sc_hd__a21oi_1
X_446_ net33 crc_reg\[30\] VGND VGND VPWR VPWR _148_ sky130_fd_sc_hd__xor2_2
XFILLER_10_243 VGND VGND VPWR VPWR sky130_fd_sc_hd__decap_8
XFILLER_24_97 VGND VGND VPWR VPWR sky130_fd_sc_hd__decap_3
XFILLER_40_85 VPWR VGND VPWR VGND sky130_ef_sc_hd__decap_12
XFILLER_40_41 VPWR VGND VPWR VGND sky130_ef_sc_hd__decap_12
XFILLER_10_276 VGND VGND VPWR VPWR sky130_fd_sc_hd__fill_2
X_429_ net9 VGND VGND VPWR VPWR _134_ sky130_fd_sc_hd__inv_2
Xinput1 data_in[0] VGND VGND VPWR VPWR net1 sky130_fd_sc_hd__buf_4
XFILLER_28_107 VPWR VGND VPWR VGND sky130_ef_sc_hd__decap_12
XFILLER_3_239 VGND VGND VPWR VPWR sky130_fd_sc_hd__fill_1
X_780_ _409_ _410_ _415_ _419_ VGND VGND VPWR VPWR _420_ sky130_fd_sc_hd__nand4_2
XFILLER_27_173 VGND VGND VPWR VPWR sky130_fd_sc_hd__fill_1
XFILLER_2_261 VPWR VGND VPWR VGND sky130_ef_sc_hd__decap_12
XFILLER_2_250 VGND VGND VPWR VPWR sky130_fd_sc_hd__fill_2
XFILLER_24_165 VGND VGND VPWR VPWR sky130_fd_sc_hd__decap_8
X_901_ clknet_3_7__leaf_clk _113_ _049_ VGND VGND VPWR VPWR crc_reg\[13\] sky130_fd_sc_hd__dfstp_1
X_694_ len_cnt\[2\] len_cnt\[1\] len_cnt\[0\] VGND VGND VPWR VPWR _366_ sky130_fd_sc_hd__and3_1
X_763_ net84 _398_ net52 VGND VGND VPWR VPWR _073_ sky130_fd_sc_hd__mux2_1
X_832_ net50 VGND VGND VPWR VPWR _046_ sky130_fd_sc_hd__inv_2
XFILLER_15_121 VGND VGND VPWR VPWR sky130_fd_sc_hd__decap_3
XFILLER_30_179 VPWR VGND VPWR VGND sky130_ef_sc_hd__decap_12
XFILLER_23_3 VPWR VGND VPWR VGND sky130_ef_sc_hd__decap_12
XTAP_TAPCELL_ROW_16_171 VGND VPWR sky130_fd_sc_hd__tapvpwrvgnd_1
XFILLER_21_113 VGND VGND VPWR VPWR sky130_fd_sc_hd__decap_8
XFILLER_21_146 VGND VGND VPWR VPWR sky130_fd_sc_hd__fill_1
XFILLER_21_157 VGND VGND VPWR VPWR sky130_fd_sc_hd__fill_2
XFILLER_29_213 VGND VGND VPWR VPWR sky130_fd_sc_hd__decap_8
XTAP_TAPCELL_ROW_39_274 VGND VPWR sky130_fd_sc_hd__tapvpwrvgnd_1
XFILLER_8_139 VGND VGND VPWR VPWR sky130_fd_sc_hd__fill_1
XFILLER_32_53 VGND VGND VPWR VPWR sky130_fd_sc_hd__fill_1
XFILLER_35_205 VGND VGND VPWR VPWR sky130_fd_sc_hd__decap_3
X_746_ net76 _404_ net31 VGND VGND VPWR VPWR _086_ sky130_fd_sc_hd__mux2_1
X_815_ net45 VGND VGND VPWR VPWR _029_ sky130_fd_sc_hd__inv_2
X_677_ _152_ _275_ VGND VGND VPWR VPWR _353_ sky130_fd_sc_hd__xor2_1
XPHY_EDGE_ROW_9_Right_9 VGND VGND VPWR VPWR sky130_fd_sc_hd__decap_3
X_531_ crc_reg\[28\] crc_reg\[12\] net61 VGND VGND VPWR VPWR _224_ sky130_fd_sc_hd__a21oi_1
X_600_ net40 crc_reg\[13\] _285_ VGND VGND VPWR VPWR _113_ sky130_fd_sc_hd__a21bo_1
XTAP_TAPCELL_ROW_4_120 VGND VPWR sky130_fd_sc_hd__tapvpwrvgnd_1
XTAP_TAPCELL_ROW_27_222 VGND VPWR sky130_fd_sc_hd__tapvpwrvgnd_1
XFILLER_40_241 VGND VGND VPWR VPWR sky130_fd_sc_hd__decap_8
X_462_ net35 _160_ _162_ VGND VGND VPWR VPWR _163_ sky130_fd_sc_hd__a21oi_1
XFILLER_25_260 VPWR VGND VPWR VGND sky130_ef_sc_hd__decap_12
XTAP_TAPCELL_ROW_10_144 VGND VPWR sky130_fd_sc_hd__tapvpwrvgnd_1
XFILLER_4_197 VPWR VGND VPWR VGND sky130_ef_sc_hd__decap_12
X_729_ len_cnt\[7\] _369_ net59 VGND VGND VPWR VPWR _393_ sky130_fd_sc_hd__a21oi_1
XTAP_TAPCELL_ROW_33_247 VGND VPWR sky130_fd_sc_hd__tapvpwrvgnd_1
XPHY_EDGE_ROW_18_Left_65 VGND VGND VPWR VPWR sky130_fd_sc_hd__decap_3
Xfanout56 net57 VGND VGND VPWR VPWR net56 sky130_fd_sc_hd__buf_2
Xfanout45 net47 VGND VGND VPWR VPWR net45 sky130_fd_sc_hd__buf_4
Xfanout34 net37 VGND VGND VPWR VPWR net34 sky130_fd_sc_hd__clkbuf_2
XFILLER_22_230 VPWR VGND VPWR VGND sky130_ef_sc_hd__decap_12
XFILLER_13_55 VGND VGND VPWR VPWR sky130_fd_sc_hd__fill_1
XFILLER_13_77 VGND VGND VPWR VPWR sky130_fd_sc_hd__fill_1
XFILLER_38_41 VGND VGND VPWR VPWR sky130_fd_sc_hd__fill_1
XFILLER_1_123 VGND VGND VPWR VPWR sky130_fd_sc_hd__decap_4
XFILLER_38_85 VPWR VGND VPWR VGND sky130_ef_sc_hd__decap_12
X_514_ crc_reg\[15\] net60 net7 VGND VGND VPWR VPWR _210_ sky130_fd_sc_hd__or3_1
X_445_ net40 crc_reg\[30\] _147_ VGND VGND VPWR VPWR _130_ sky130_fd_sc_hd__a21o_1
XFILLER_9_245 VPWR VGND VPWR VGND sky130_ef_sc_hd__decap_12
XFILLER_24_65 VGND VGND VPWR VPWR sky130_fd_sc_hd__decap_8
XFILLER_40_97 VPWR VGND VPWR VGND sky130_ef_sc_hd__decap_12
XFILLER_40_53 VPWR VGND VPWR VGND sky130_ef_sc_hd__decap_12
XFILLER_45_152 VPWR VGND VPWR VGND sky130_ef_sc_hd__decap_12
X_428_ net58 VGND VGND VPWR VPWR _133_ sky130_fd_sc_hd__inv_2
XFILLER_36_141 VGND VGND VPWR VPWR sky130_fd_sc_hd__decap_6
Xinput2 data_in[1] VGND VGND VPWR VPWR net2 sky130_fd_sc_hd__clkbuf_8
XFILLER_3_229 VGND VGND VPWR VPWR sky130_fd_sc_hd__fill_1
XFILLER_2_273 VGND VGND VPWR VPWR sky130_fd_sc_hd__decap_4
XFILLER_18_141 VPWR VGND VPWR VGND sky130_ef_sc_hd__decap_12
X_900_ clknet_3_7__leaf_clk _112_ _048_ VGND VGND VPWR VPWR crc_reg\[12\] sky130_fd_sc_hd__dfstp_1
X_831_ net47 VGND VGND VPWR VPWR _045_ sky130_fd_sc_hd__inv_2
XFILLER_46_85 VPWR VGND VPWR VGND sky130_ef_sc_hd__decap_12
XFILLER_46_41 VPWR VGND VPWR VGND sky130_ef_sc_hd__decap_12
X_762_ net81 _396_ net51 VGND VGND VPWR VPWR _074_ sky130_fd_sc_hd__mux2_1
XPHY_EDGE_ROW_6_Left_53 VGND VGND VPWR VPWR sky130_fd_sc_hd__decap_3
X_693_ net53 net9 VGND VGND VPWR VPWR _365_ sky130_fd_sc_hd__nand2_1
XFILLER_15_111 VGND VGND VPWR VPWR sky130_fd_sc_hd__fill_1
XFILLER_16_3 VPWR VGND VPWR VGND sky130_ef_sc_hd__decap_12
XFILLER_21_103 VGND VGND VPWR VPWR sky130_fd_sc_hd__decap_8
XTAP_TAPCELL_ROW_16_172 VGND VPWR sky130_fd_sc_hd__tapvpwrvgnd_1
XTAP_TAPCELL_ROW_39_275 VGND VPWR sky130_fd_sc_hd__tapvpwrvgnd_1
XFILLER_29_225 VPWR VGND VPWR VGND sky130_ef_sc_hd__decap_12
XFILLER_12_136 VGND VGND VPWR VPWR sky130_fd_sc_hd__decap_4
XPHY_EDGE_ROW_32_Left_79 VGND VGND VPWR VPWR sky130_fd_sc_hd__decap_3
XTAP_TAPCELL_ROW_22_197 VGND VPWR sky130_fd_sc_hd__tapvpwrvgnd_1
X_814_ net45 VGND VGND VPWR VPWR _028_ sky130_fd_sc_hd__inv_2
X_676_ crc_reg\[4\] _352_ net56 VGND VGND VPWR VPWR _104_ sky130_fd_sc_hd__mux2_1
X_745_ net59 _366_ _403_ VGND VGND VPWR VPWR _404_ sky130_fd_sc_hd__nor3_1
X_530_ crc_reg\[21\] _223_ net55 VGND VGND VPWR VPWR _121_ sky130_fd_sc_hd__mux2_1
X_461_ net6 _161_ VGND VGND VPWR VPWR _162_ sky130_fd_sc_hd__xor2_1
XTAP_TAPCELL_ROW_27_223 VGND VPWR sky130_fd_sc_hd__tapvpwrvgnd_1
XFILLER_40_253 VPWR VGND VPWR VGND sky130_ef_sc_hd__decap_12
XFILLER_25_272 VGND VGND VPWR VPWR sky130_fd_sc_hd__decap_6
XTAP_TAPCELL_ROW_10_145 VGND VPWR sky130_fd_sc_hd__tapvpwrvgnd_1
X_728_ net72 _392_ net32 VGND VGND VPWR VPWR _092_ sky130_fd_sc_hd__mux2_1
XFILLER_16_272 VGND VGND VPWR VPWR sky130_fd_sc_hd__fill_2
X_659_ _273_ _337_ VGND VGND VPWR VPWR _338_ sky130_fd_sc_hd__xnor2_1
XTAP_TAPCELL_ROW_33_248 VGND VPWR sky130_fd_sc_hd__tapvpwrvgnd_1
Xfanout57 net11 VGND VGND VPWR VPWR net57 sky130_fd_sc_hd__clkbuf_2
Xfanout35 net37 VGND VGND VPWR VPWR net35 sky130_fd_sc_hd__buf_2
Xfanout46 net47 VGND VGND VPWR VPWR net46 sky130_fd_sc_hd__buf_2
XFILLER_22_242 VGND VGND VPWR VPWR sky130_fd_sc_hd__decap_8
XFILLER_22_253 VPWR VGND VPWR VGND sky130_ef_sc_hd__decap_12
XFILLER_1_113 VGND VGND VPWR VPWR sky130_fd_sc_hd__fill_1
XFILLER_38_97 VGND VGND VPWR VPWR sky130_fd_sc_hd__decap_3
X_444_ net55 _145_ _146_ VGND VGND VPWR VPWR _147_ sky130_fd_sc_hd__and3_1
X_513_ crc_reg\[15\] net60 net7 VGND VGND VPWR VPWR _209_ sky130_fd_sc_hd__o21ai_1
XPHY_EDGE_ROW_35_Left_82 VGND VGND VPWR VPWR sky130_fd_sc_hd__decap_3
XFILLER_9_257 VGND VGND VPWR VPWR sky130_fd_sc_hd__decap_8
XFILLER_9_268 VGND VGND VPWR VPWR sky130_fd_sc_hd__decap_6
XFILLER_46_109 VGND VGND VPWR VPWR sky130_fd_sc_hd__decap_3
XFILLER_40_65 VGND VGND VPWR VPWR sky130_fd_sc_hd__decap_3
XFILLER_1_15 VPWR VGND VPWR VGND sky130_ef_sc_hd__decap_12
XFILLER_45_175 VPWR VGND VPWR VGND sky130_ef_sc_hd__decap_12
XFILLER_45_164 VGND VGND VPWR VPWR sky130_fd_sc_hd__decap_4
X_427_ net51 VGND VGND VPWR VPWR _132_ sky130_fd_sc_hd__inv_2
XFILLER_46_3 VPWR VGND VPWR VGND sky130_ef_sc_hd__decap_12
XPHY_EDGE_ROW_18_Right_18 VGND VGND VPWR VPWR sky130_fd_sc_hd__decap_3
XPHY_EDGE_ROW_27_Right_27 VGND VGND VPWR VPWR sky130_fd_sc_hd__decap_3
Xinput3 data_in[2] VGND VGND VPWR VPWR net3 sky130_fd_sc_hd__buf_4
XPHY_EDGE_ROW_36_Right_36 VGND VGND VPWR VPWR sky130_fd_sc_hd__decap_3
XFILLER_27_153 VGND VGND VPWR VPWR sky130_fd_sc_hd__fill_1
XPHY_EDGE_ROW_45_Right_45 VGND VGND VPWR VPWR sky130_fd_sc_hd__decap_3
XFILLER_42_101 VGND VGND VPWR VPWR sky130_fd_sc_hd__fill_1
XFILLER_35_65 VGND VGND VPWR VPWR sky130_fd_sc_hd__decap_6
XFILLER_18_153 VGND VGND VPWR VPWR sky130_fd_sc_hd__decap_3
XFILLER_18_197 VGND VGND VPWR VPWR sky130_fd_sc_hd__decap_4
XFILLER_33_167 VGND VGND VPWR VPWR sky130_fd_sc_hd__fill_1
X_761_ len_cnt\[7\] _394_ net51 VGND VGND VPWR VPWR _075_ sky130_fd_sc_hd__mux2_1
X_830_ net44 VGND VGND VPWR VPWR _044_ sky130_fd_sc_hd__inv_2
XFILLER_46_97 VPWR VGND VPWR VGND sky130_ef_sc_hd__decap_12
XFILLER_46_53 VGND VGND VPWR VPWR sky130_fd_sc_hd__decap_3
X_692_ net41 _134_ VGND VGND VPWR VPWR _364_ sky130_fd_sc_hd__nor2_1
XFILLER_38_215 VPWR VGND VPWR VGND sky130_ef_sc_hd__decap_12
XTAP_TAPCELL_ROW_16_173 VGND VPWR sky130_fd_sc_hd__tapvpwrvgnd_1
XTAP_TAPCELL_ROW_39_276 VGND VPWR sky130_fd_sc_hd__tapvpwrvgnd_1
XFILLER_29_237 VGND VGND VPWR VPWR sky130_fd_sc_hd__fill_1
XFILLER_29_259 VPWR VGND VPWR VGND sky130_ef_sc_hd__decap_12
XPHY_EDGE_ROW_0_Right_0 VGND VGND VPWR VPWR sky130_fd_sc_hd__decap_3
XTAP_TAPCELL_ROW_22_198 VGND VPWR sky130_fd_sc_hd__tapvpwrvgnd_1
XTAP_TAPCELL_ROW_7_130 VGND VPWR sky130_fd_sc_hd__tapvpwrvgnd_1
X_813_ net43 VGND VGND VPWR VPWR _027_ sky130_fd_sc_hd__inv_2
X_744_ len_cnt\[1\] len_cnt\[0\] len_cnt\[2\] VGND VGND VPWR VPWR _403_ sky130_fd_sc_hd__a21oi_1
XFILLER_43_251 VPWR VGND VPWR VGND sky130_ef_sc_hd__decap_12
X_675_ _349_ _351_ VGND VGND VPWR VPWR _352_ sky130_fd_sc_hd__xnor2_1
XFILLER_11_181 VPWR VGND VPWR VGND sky130_ef_sc_hd__decap_12
X_460_ net2 net3 VGND VGND VPWR VPWR _161_ sky130_fd_sc_hd__xor2_4
XFILLER_17_218 VGND VGND VPWR VPWR sky130_fd_sc_hd__decap_6
XFILLER_27_66 VGND VGND VPWR VPWR sky130_fd_sc_hd__decap_6
XFILLER_40_265 VPWR VGND VPWR VGND sky130_ef_sc_hd__decap_12
XTAP_TAPCELL_ROW_10_146 VGND VPWR sky130_fd_sc_hd__tapvpwrvgnd_1
XFILLER_4_122 VPWR VGND VPWR VGND sky130_ef_sc_hd__decap_12
XFILLER_4_15 VPWR VGND VPWR VGND sky130_ef_sc_hd__decap_12
X_727_ net58 _370_ _391_ VGND VGND VPWR VPWR _392_ sky130_fd_sc_hd__nor3_1
XFILLER_16_240 VPWR VGND VPWR VGND sky130_ef_sc_hd__decap_12
X_658_ _172_ _238_ VGND VGND VPWR VPWR _337_ sky130_fd_sc_hd__xnor2_1
X_589_ net7 net6 VGND VGND VPWR VPWR _275_ sky130_fd_sc_hd__xnor2_2
XTAP_TAPCELL_ROW_33_249 VGND VPWR sky130_fd_sc_hd__tapvpwrvgnd_1
XTAP_TAPCELL_ROW_1_103 VGND VPWR sky130_fd_sc_hd__tapvpwrvgnd_1
Xfanout58 net62 VGND VGND VPWR VPWR net58 sky130_fd_sc_hd__buf_2
Xfanout47 net50 VGND VGND VPWR VPWR net47 sky130_fd_sc_hd__buf_4
XFILLER_13_57 VPWR VGND VPWR VGND sky130_ef_sc_hd__decap_12
Xfanout36 net37 VGND VGND VPWR VPWR net36 sky130_fd_sc_hd__buf_2
XFILLER_22_265 VPWR VGND VPWR VGND sky130_ef_sc_hd__decap_12
XFILLER_1_147 VGND VGND VPWR VPWR sky130_fd_sc_hd__decap_8
XFILLER_1_169 VGND VGND VPWR VPWR sky130_fd_sc_hd__fill_2
X_443_ net61 _142_ _143_ _144_ VGND VGND VPWR VPWR _146_ sky130_fd_sc_hd__o31ai_1
XFILLER_9_225 VPWR VGND VPWR VGND sky130_ef_sc_hd__decap_12
X_512_ crc_reg\[30\] _207_ VGND VGND VPWR VPWR _208_ sky130_fd_sc_hd__xnor2_1
XFILLER_39_151 VPWR VGND VPWR VGND sky130_ef_sc_hd__decap_12
XFILLER_6_228 VGND VGND VPWR VPWR sky130_fd_sc_hd__decap_3
XFILLER_10_268 VGND VGND VPWR VPWR sky130_fd_sc_hd__decap_8
XFILLER_24_78 VGND VGND VPWR VPWR sky130_fd_sc_hd__decap_6
XFILLER_6_3 VPWR VGND VPWR VGND sky130_ef_sc_hd__decap_12
XFILLER_45_187 VPWR VGND VPWR VGND sky130_ef_sc_hd__decap_12
XFILLER_1_27 VPWR VGND VPWR VGND sky130_ef_sc_hd__decap_12
Xinput4 data_in[3] VGND VGND VPWR VPWR net4 sky130_fd_sc_hd__buf_4
XFILLER_36_154 VPWR VGND VPWR VGND sky130_ef_sc_hd__decap_12
XFILLER_35_33 VGND VGND VPWR VPWR sky130_fd_sc_hd__fill_1
XFILLER_27_110 VGND VGND VPWR VPWR sky130_fd_sc_hd__fill_2
XFILLER_35_55 VGND VGND VPWR VPWR sky130_fd_sc_hd__fill_1
XFILLER_27_187 VPWR VGND VPWR VGND sky130_ef_sc_hd__decap_12
XFILLER_18_121 VGND VGND VPWR VPWR sky130_fd_sc_hd__fill_1
XFILLER_33_113 VPWR VGND VPWR VGND sky130_ef_sc_hd__decap_12
XFILLER_21_79 VGND VGND VPWR VPWR sky130_fd_sc_hd__decap_6
X_760_ net87 _392_ net53 VGND VGND VPWR VPWR _076_ sky130_fd_sc_hd__mux2_1
X_691_ crc_reg\[0\] _363_ net54 VGND VGND VPWR VPWR _100_ sky130_fd_sc_hd__mux2_1
XFILLER_15_102 VGND VGND VPWR VPWR sky130_fd_sc_hd__fill_1
XFILLER_15_113 VGND VGND VPWR VPWR sky130_fd_sc_hd__decap_8
XFILLER_30_138 VGND VGND VPWR VPWR sky130_fd_sc_hd__fill_2
XFILLER_38_227 VGND VGND VPWR VPWR sky130_fd_sc_hd__fill_1
X_889_ clknet_3_4__leaf_clk _101_ _037_ VGND VGND VPWR VPWR crc_reg\[1\] sky130_fd_sc_hd__dfstp_1
XTAP_TAPCELL_ROW_16_174 VGND VPWR sky130_fd_sc_hd__tapvpwrvgnd_1
XTAP_TAPCELL_ROW_39_277 VGND VPWR sky130_fd_sc_hd__tapvpwrvgnd_1
XTAP_TAPCELL_ROW_22_199 VGND VPWR sky130_fd_sc_hd__tapvpwrvgnd_1
XTAP_TAPCELL_ROW_7_131 VGND VPWR sky130_fd_sc_hd__tapvpwrvgnd_1
X_812_ net43 VGND VGND VPWR VPWR _026_ sky130_fd_sc_hd__inv_2
X_743_ net69 _402_ net31 VGND VGND VPWR VPWR _087_ sky130_fd_sc_hd__mux2_1
X_674_ _309_ _350_ VGND VGND VPWR VPWR _351_ sky130_fd_sc_hd__xnor2_1
XFILLER_43_263 VPWR VGND VPWR VGND sky130_ef_sc_hd__decap_12
XFILLER_7_142 VPWR VGND VPWR VGND sky130_ef_sc_hd__decap_12
XFILLER_11_193 VPWR VGND VPWR VGND sky130_ef_sc_hd__decap_12
XFILLER_21_3 VPWR VGND VPWR VGND sky130_ef_sc_hd__decap_12
XFILLER_34_230 VGND VGND VPWR VPWR sky130_fd_sc_hd__fill_1
XFILLER_40_233 VGND VGND VPWR VPWR sky130_fd_sc_hd__fill_1
XFILLER_27_78 VGND VGND VPWR VPWR sky130_fd_sc_hd__decap_4
XFILLER_40_277 VGND VGND VPWR VPWR sky130_fd_sc_hd__fill_1
XTAP_TAPCELL_ROW_10_147 VGND VPWR sky130_fd_sc_hd__tapvpwrvgnd_1
XFILLER_4_134 VGND VGND VPWR VPWR sky130_fd_sc_hd__decap_6
XFILLER_4_27 VGND VGND VPWR VPWR sky130_fd_sc_hd__fill_1
X_726_ len_cnt\[7\] _369_ len_cnt\[8\] VGND VGND VPWR VPWR _391_ sky130_fd_sc_hd__a21oi_1
X_657_ net53 crc_reg\[6\] VGND VGND VPWR VPWR _336_ sky130_fd_sc_hd__or2_1
XTAP_TAPCELL_ROW_41_283 VGND VPWR sky130_fd_sc_hd__tapvpwrvgnd_1
X_588_ _152_ _161_ VGND VGND VPWR VPWR _274_ sky130_fd_sc_hd__xnor2_1
XFILLER_31_277 VGND VGND VPWR VPWR sky130_fd_sc_hd__fill_1
XTAP_TAPCELL_ROW_1_104 VGND VPWR sky130_fd_sc_hd__tapvpwrvgnd_1
Xfanout37 _133_ VGND VGND VPWR VPWR net37 sky130_fd_sc_hd__clkbuf_2
XTAP_TAPCELL_ROW_24_206 VGND VPWR sky130_fd_sc_hd__tapvpwrvgnd_1
Xfanout59 net62 VGND VGND VPWR VPWR net59 sky130_fd_sc_hd__buf_2
XFILLER_13_69 VGND VGND VPWR VPWR sky130_fd_sc_hd__decap_8
XFILLER_22_277 VGND VGND VPWR VPWR sky130_fd_sc_hd__fill_1
Xfanout48 net50 VGND VGND VPWR VPWR net48 sky130_fd_sc_hd__buf_4
XFILLER_38_77 VGND VGND VPWR VPWR sky130_fd_sc_hd__decap_6
X_511_ crc_reg\[25\] crc_reg\[24\] VGND VGND VPWR VPWR _207_ sky130_fd_sc_hd__xnor2_4
X_442_ net61 _142_ _143_ _144_ VGND VGND VPWR VPWR _145_ sky130_fd_sc_hd__or4_1
XFILLER_9_237 VGND VGND VPWR VPWR sky130_fd_sc_hd__fill_2
XFILLER_13_222 VGND VGND VPWR VPWR sky130_fd_sc_hd__fill_2
XFILLER_13_255 VGND VGND VPWR VPWR sky130_fd_sc_hd__decap_3
XFILLER_13_277 VGND VGND VPWR VPWR sky130_fd_sc_hd__fill_1
X_709_ _378_ _379_ VGND VGND VPWR VPWR _380_ sky130_fd_sc_hd__nor2_1
XFILLER_5_70 VGND VGND VPWR VPWR sky130_fd_sc_hd__decap_8
XFILLER_39_163 VGND VGND VPWR VPWR sky130_fd_sc_hd__decap_4
XFILLER_45_199 VGND VGND VPWR VPWR sky130_fd_sc_hd__decap_6
XFILLER_45_111 VGND VGND VPWR VPWR sky130_fd_sc_hd__fill_1
XFILLER_1_39 VGND VGND VPWR VPWR sky130_fd_sc_hd__decap_3
XFILLER_5_251 VPWR VGND VPWR VGND sky130_ef_sc_hd__decap_12
Xinput5 data_in[4] VGND VGND VPWR VPWR net5 sky130_fd_sc_hd__buf_4
XFILLER_36_166 VPWR VGND VPWR VGND sky130_ef_sc_hd__decap_12
XFILLER_10_15 VPWR VGND VPWR VGND sky130_ef_sc_hd__decap_12
XFILLER_19_57 VPWR VGND VPWR VGND sky130_ef_sc_hd__decap_12
XFILLER_27_144 VGND VGND VPWR VPWR sky130_fd_sc_hd__fill_2
XFILLER_27_199 VGND VGND VPWR VPWR sky130_fd_sc_hd__decap_3
XFILLER_33_103 VGND VGND VPWR VPWR sky130_fd_sc_hd__fill_2
XFILLER_33_125 VPWR VGND VPWR VGND sky130_ef_sc_hd__decap_12
XFILLER_33_169 VPWR VGND VPWR VGND sky130_ef_sc_hd__decap_12
XFILLER_32_180 VGND VGND VPWR VPWR sky130_fd_sc_hd__decap_6
X_690_ _184_ _362_ VGND VGND VPWR VPWR _363_ sky130_fd_sc_hd__xnor2_1
XFILLER_15_136 VGND VGND VPWR VPWR sky130_fd_sc_hd__decap_4
XFILLER_15_169 VPWR VGND VPWR VGND sky130_ef_sc_hd__decap_12
X_888_ clknet_3_6__leaf_clk _100_ _036_ VGND VGND VPWR VPWR crc_reg\[0\] sky130_fd_sc_hd__dfstp_1
XFILLER_20_172 VPWR VGND VPWR VGND sky130_ef_sc_hd__decap_12
XTAP_TAPCELL_ROW_7_132 VGND VPWR sky130_fd_sc_hd__tapvpwrvgnd_1
X_811_ net43 VGND VGND VPWR VPWR _025_ sky130_fd_sc_hd__inv_2
X_742_ len_cnt\[3\] _366_ _401_ VGND VGND VPWR VPWR _402_ sky130_fd_sc_hd__o21a_1
XFILLER_28_250 VGND VGND VPWR VPWR sky130_fd_sc_hd__fill_2
X_673_ net2 net4 VGND VGND VPWR VPWR _350_ sky130_fd_sc_hd__xor2_1
XFILLER_43_275 VGND VGND VPWR VPWR sky130_fd_sc_hd__decap_3
XFILLER_7_154 VGND VGND VPWR VPWR sky130_fd_sc_hd__decap_4
XFILLER_14_3 VPWR VGND VPWR VGND sky130_ef_sc_hd__decap_12
XFILLER_19_261 VGND VGND VPWR VPWR sky130_fd_sc_hd__fill_2
XFILLER_26_209 VGND VGND VPWR VPWR sky130_fd_sc_hd__decap_4
XFILLER_43_78 VGND VGND VPWR VPWR sky130_fd_sc_hd__decap_6
X_725_ net65 _390_ net32 VGND VGND VPWR VPWR _093_ sky130_fd_sc_hd__mux2_1
X_656_ net54 net89 _335_ VGND VGND VPWR VPWR _107_ sky130_fd_sc_hd__o21ba_1
XFILLER_16_253 VGND VGND VPWR VPWR sky130_fd_sc_hd__decap_8
XFILLER_16_264 VGND VGND VPWR VPWR sky130_fd_sc_hd__decap_8
X_587_ net60 _149_ VGND VGND VPWR VPWR _273_ sky130_fd_sc_hd__nor2_1
XTAP_TAPCELL_ROW_41_284 VGND VPWR sky130_fd_sc_hd__tapvpwrvgnd_1
XFILLER_31_223 VGND VGND VPWR VPWR sky130_fd_sc_hd__fill_1
XTAP_TAPCELL_ROW_1_105 VGND VPWR sky130_fd_sc_hd__tapvpwrvgnd_1
Xfanout38 net41 VGND VGND VPWR VPWR net38 sky130_fd_sc_hd__buf_2
XFILLER_13_15 VGND VGND VPWR VPWR sky130_fd_sc_hd__decap_4
XTAP_TAPCELL_ROW_24_207 VGND VPWR sky130_fd_sc_hd__tapvpwrvgnd_1
Xfanout49 net50 VGND VGND VPWR VPWR net49 sky130_fd_sc_hd__buf_4
X_441_ net1 net4 VGND VGND VPWR VPWR _144_ sky130_fd_sc_hd__xor2_1
X_510_ net55 _204_ _205_ _206_ VGND VGND VPWR VPWR _124_ sky130_fd_sc_hd__a31o_1
XFILLER_13_267 VGND VGND VPWR VPWR sky130_fd_sc_hd__fill_2
XFILLER_0_182 VGND VGND VPWR VPWR sky130_fd_sc_hd__decap_3
XTAP_TAPCELL_ROW_46_310 VGND VPWR sky130_fd_sc_hd__tapvpwrvgnd_1
X_708_ len_cnt\[14\] len_cnt\[13\] _373_ net58 VGND VGND VPWR VPWR _379_ sky130_fd_sc_hd__a31o_1
X_639_ _275_ _320_ VGND VGND VPWR VPWR _321_ sky130_fd_sc_hd__xnor2_1
XPHY_EDGE_ROW_39_Left_86 VGND VGND VPWR VPWR sky130_fd_sc_hd__decap_3
XFILLER_5_263 VPWR VGND VPWR VGND sky130_ef_sc_hd__decap_12
Xinput6 data_in[5] VGND VGND VPWR VPWR net6 sky130_fd_sc_hd__clkbuf_4
XFILLER_36_178 VPWR VGND VPWR VGND sky130_ef_sc_hd__decap_12
XFILLER_10_27 VGND VGND VPWR VPWR sky130_fd_sc_hd__fill_1
XFILLER_19_69 VPWR VGND VPWR VGND sky130_ef_sc_hd__decap_12
XFILLER_42_115 VGND VGND VPWR VPWR sky130_fd_sc_hd__fill_1
XFILLER_27_167 VGND VGND VPWR VPWR sky130_fd_sc_hd__fill_1
Xclkbuf_3_3__f_clk clknet_0_clk VGND VGND VPWR VPWR clknet_3_3__leaf_clk sky130_fd_sc_hd__clkbuf_16
XPHY_EDGE_ROW_14_Right_14 VGND VGND VPWR VPWR sky130_fd_sc_hd__decap_3
XFILLER_2_277 VGND VGND VPWR VPWR sky130_fd_sc_hd__fill_1
XPHY_EDGE_ROW_23_Right_23 VGND VGND VPWR VPWR sky130_fd_sc_hd__decap_3
XFILLER_41_181 VPWR VGND VPWR VGND sky130_ef_sc_hd__decap_12
XPHY_EDGE_ROW_32_Right_32 VGND VGND VPWR VPWR sky130_fd_sc_hd__decap_3
XFILLER_33_137 VPWR VGND VPWR VGND sky130_ef_sc_hd__decap_12
XFILLER_44_3 VPWR VGND VPWR VGND sky130_ef_sc_hd__decap_12
XPHY_EDGE_ROW_41_Right_41 VGND VGND VPWR VPWR sky130_fd_sc_hd__decap_3
XTAP_TAPCELL_ROW_19_184 VGND VPWR sky130_fd_sc_hd__tapvpwrvgnd_1
XFILLER_21_15 VPWR VGND VPWR VGND sky130_ef_sc_hd__decap_12
X_887_ clknet_3_3__leaf_clk _099_ _035_ VGND VGND VPWR VPWR net21 sky130_fd_sc_hd__dfrtp_1
XFILLER_14_181 VPWR VGND VPWR VGND sky130_ef_sc_hd__decap_12
XPHY_EDGE_ROW_26_Left_73 VGND VGND VPWR VPWR sky130_fd_sc_hd__decap_3
XPHY_EDGE_ROW_10_Left_57 VGND VGND VPWR VPWR sky130_fd_sc_hd__decap_3
XFILLER_37_240 VPWR VGND VPWR VGND sky130_ef_sc_hd__decap_12
XFILLER_16_15 VPWR VGND VPWR VGND sky130_ef_sc_hd__decap_12
XFILLER_20_184 VGND VGND VPWR VPWR sky130_fd_sc_hd__decap_6
XTAP_TAPCELL_ROW_7_133 VGND VPWR sky130_fd_sc_hd__tapvpwrvgnd_1
X_810_ net42 VGND VGND VPWR VPWR _024_ sky130_fd_sc_hd__inv_2
X_741_ net59 _367_ VGND VGND VPWR VPWR _401_ sky130_fd_sc_hd__nor2_1
X_672_ _313_ _348_ VGND VGND VPWR VPWR _349_ sky130_fd_sc_hd__xnor2_1
XFILLER_7_111 VGND VGND VPWR VPWR sky130_fd_sc_hd__fill_1
XTAP_TAPCELL_ROW_13_157 VGND VPWR sky130_fd_sc_hd__tapvpwrvgnd_1
XFILLER_22_80 VGND VGND VPWR VPWR sky130_fd_sc_hd__decap_4
XFILLER_34_276 VGND VGND VPWR VPWR sky130_fd_sc_hd__fill_2
XFILLER_34_221 VGND VGND VPWR VPWR sky130_fd_sc_hd__fill_2
XFILLER_8_60 VPWR VGND VPWR VGND sky130_ef_sc_hd__decap_12
XPHY_EDGE_ROW_4_Right_4 VGND VGND VPWR VPWR sky130_fd_sc_hd__decap_3
XFILLER_4_147 VPWR VGND VPWR VGND sky130_ef_sc_hd__decap_12
XFILLER_4_29 VPWR VGND VPWR VGND sky130_ef_sc_hd__decap_12
X_724_ len_cnt\[9\] _370_ _389_ VGND VGND VPWR VPWR _390_ sky130_fd_sc_hd__o21a_1
X_655_ net54 _333_ _334_ VGND VGND VPWR VPWR _335_ sky130_fd_sc_hd__and3_1
X_586_ _148_ _270_ net61 VGND VGND VPWR VPWR _272_ sky130_fd_sc_hd__a21oi_1
XTAP_TAPCELL_ROW_41_285 VGND VPWR sky130_fd_sc_hd__tapvpwrvgnd_1
XTAP_TAPCELL_ROW_1_106 VGND VPWR sky130_fd_sc_hd__tapvpwrvgnd_1
XTAP_TAPCELL_ROW_24_208 VGND VPWR sky130_fd_sc_hd__tapvpwrvgnd_1
Xfanout39 net41 VGND VGND VPWR VPWR net39 sky130_fd_sc_hd__buf_2
XPHY_EDGE_ROW_13_Left_60 VGND VGND VPWR VPWR sky130_fd_sc_hd__decap_3
X_440_ crc_reg\[31\] _140_ _141_ VGND VGND VPWR VPWR _143_ sky130_fd_sc_hd__nor3_1
XFILLER_13_202 VGND VGND VPWR VPWR sky130_fd_sc_hd__fill_2
XTAP_TAPCELL_ROW_46_311 VGND VPWR sky130_fd_sc_hd__tapvpwrvgnd_1
X_707_ len_cnt\[13\] _373_ len_cnt\[14\] VGND VGND VPWR VPWR _378_ sky130_fd_sc_hd__a21oi_1
X_569_ _178_ _256_ VGND VGND VPWR VPWR _257_ sky130_fd_sc_hd__xnor2_1
X_638_ crc_reg\[1\] net60 VGND VGND VPWR VPWR _320_ sky130_fd_sc_hd__nor2_1
XFILLER_39_110 VGND VGND VPWR VPWR sky130_fd_sc_hd__fill_2
XFILLER_39_198 VGND VGND VPWR VPWR sky130_fd_sc_hd__fill_1
XFILLER_24_15 VPWR VGND VPWR VGND sky130_ef_sc_hd__decap_12
XFILLER_6_209 VGND VGND VPWR VPWR sky130_fd_sc_hd__fill_2
XFILLER_45_113 VPWR VGND VPWR VGND sky130_ef_sc_hd__decap_12
XFILLER_14_81 VGND VGND VPWR VPWR sky130_fd_sc_hd__decap_3
XFILLER_5_275 VGND VGND VPWR VPWR sky130_fd_sc_hd__decap_3
Xinput7 data_in[6] VGND VGND VPWR VPWR net7 sky130_fd_sc_hd__buf_4
XPHY_EDGE_ROW_40_Left_87 VGND VGND VPWR VPWR sky130_fd_sc_hd__decap_3
XFILLER_19_15 VPWR VGND VPWR VGND sky130_ef_sc_hd__decap_12
XFILLER_19_48 VGND VGND VPWR VPWR sky130_fd_sc_hd__decap_8
XFILLER_27_102 VGND VGND VPWR VPWR sky130_fd_sc_hd__decap_8
XFILLER_27_113 VPWR VGND VPWR VGND sky130_ef_sc_hd__decap_12
XFILLER_35_190 VGND VGND VPWR VPWR sky130_fd_sc_hd__fill_1
XFILLER_4_3 VPWR VGND VPWR VGND sky130_ef_sc_hd__decap_12
XFILLER_41_193 VGND VGND VPWR VPWR sky130_fd_sc_hd__decap_3
XFILLER_26_190 VGND VGND VPWR VPWR sky130_fd_sc_hd__decap_6
XFILLER_33_149 VPWR VGND VPWR VGND sky130_ef_sc_hd__decap_12
XFILLER_37_3 VPWR VGND VPWR VGND sky130_ef_sc_hd__decap_12
XTAP_TAPCELL_ROW_19_185 VGND VPWR sky130_fd_sc_hd__tapvpwrvgnd_1
XFILLER_21_27 VGND VGND VPWR VPWR sky130_fd_sc_hd__decap_8
XFILLER_32_193 VGND VGND VPWR VPWR sky130_fd_sc_hd__decap_3
XFILLER_46_57 VPWR VGND VPWR VGND sky130_ef_sc_hd__decap_12
XFILLER_11_60 VGND VGND VPWR VPWR sky130_fd_sc_hd__decap_8
X_886_ clknet_3_3__leaf_clk _098_ _034_ VGND VGND VPWR VPWR net20 sky130_fd_sc_hd__dfrtp_1
Xinput10 in_sop VGND VGND VPWR VPWR net10 sky130_fd_sc_hd__clkbuf_1
XFILLER_37_252 VPWR VGND VPWR VGND sky130_ef_sc_hd__decap_12
XFILLER_16_27 VGND VGND VPWR VPWR sky130_fd_sc_hd__fill_1
XFILLER_20_141 VPWR VGND VPWR VGND sky130_ef_sc_hd__decap_12
XFILLER_32_15 VPWR VGND VPWR VGND sky130_ef_sc_hd__decap_12
X_740_ net75 _400_ net31 VGND VGND VPWR VPWR _088_ sky130_fd_sc_hd__mux2_1
XFILLER_43_222 VGND VGND VPWR VPWR sky130_fd_sc_hd__fill_2
XPHY_EDGE_ROW_43_Left_90 VGND VGND VPWR VPWR sky130_fd_sc_hd__decap_3
X_671_ crc_reg\[30\] crc_reg\[28\] _347_ VGND VGND VPWR VPWR _348_ sky130_fd_sc_hd__o21ai_1
XFILLER_11_141 VPWR VGND VPWR VGND sky130_ef_sc_hd__decap_12
XTAP_TAPCELL_ROW_13_158 VGND VPWR sky130_fd_sc_hd__tapvpwrvgnd_1
XFILLER_7_189 VGND VGND VPWR VPWR sky130_fd_sc_hd__fill_2
XFILLER_7_167 VGND VGND VPWR VPWR sky130_fd_sc_hd__fill_1
X_869_ clknet_3_3__leaf_clk _083_ _017_ VGND VGND VPWR VPWR len_cnt\[15\] sky130_fd_sc_hd__dfrtp_1
XFILLER_8_72 VPWR VGND VPWR VGND sky130_ef_sc_hd__decap_12
XFILLER_27_15 VPWR VGND VPWR VGND sky130_ef_sc_hd__decap_12
XFILLER_4_159 VPWR VGND VPWR VGND sky130_ef_sc_hd__decap_12
X_723_ net58 _371_ VGND VGND VPWR VPWR _389_ sky130_fd_sc_hd__nor2_1
X_654_ net36 _308_ _332_ VGND VGND VPWR VPWR _334_ sky130_fd_sc_hd__nand3_1
X_585_ _148_ _270_ VGND VGND VPWR VPWR _271_ sky130_fd_sc_hd__or2_1
XFILLER_31_225 VPWR VGND VPWR VGND sky130_ef_sc_hd__decap_12
XTAP_TAPCELL_ROW_41_286 VGND VPWR sky130_fd_sc_hd__tapvpwrvgnd_1
XFILLER_33_91 VPWR VGND VPWR VGND sky130_ef_sc_hd__decap_12
XFILLER_13_39 VPWR VGND VPWR VGND sky130_ef_sc_hd__decap_12
XTAP_TAPCELL_ROW_24_209 VGND VPWR sky130_fd_sc_hd__tapvpwrvgnd_1
XTAP_TAPCELL_ROW_32_242 VGND VPWR sky130_fd_sc_hd__tapvpwrvgnd_1
XFILLER_1_107 VGND VGND VPWR VPWR sky130_fd_sc_hd__decap_4
XFILLER_13_225 VGND VGND VPWR VPWR sky130_fd_sc_hd__decap_4
XFILLER_13_247 VGND VGND VPWR VPWR sky130_fd_sc_hd__decap_8
XTAP_TAPCELL_ROW_46_312 VGND VPWR sky130_fd_sc_hd__tapvpwrvgnd_1
X_706_ _365_ _376_ _377_ VGND VGND VPWR VPWR _099_ sky130_fd_sc_hd__o21ai_1
X_637_ net36 _317_ _171_ VGND VGND VPWR VPWR _319_ sky130_fd_sc_hd__a21o_1
X_568_ crc_reg\[29\] crc_reg\[7\] VGND VGND VPWR VPWR _256_ sky130_fd_sc_hd__xnor2_1
X_499_ crc_reg\[31\] net61 VGND VGND VPWR VPWR _196_ sky130_fd_sc_hd__nor2_1
XFILLER_5_51 VGND VGND VPWR VPWR sky130_fd_sc_hd__decap_4
XFILLER_39_133 VGND VGND VPWR VPWR sky130_fd_sc_hd__fill_2
XFILLER_24_27 VGND VGND VPWR VPWR sky130_fd_sc_hd__fill_1
XFILLER_40_15 VPWR VGND VPWR VGND sky130_ef_sc_hd__decap_12
XFILLER_45_169 VGND VGND VPWR VPWR sky130_fd_sc_hd__fill_2
XFILLER_45_125 VPWR VGND VPWR VGND sky130_ef_sc_hd__decap_12
XFILLER_45_103 VGND VGND VPWR VPWR sky130_fd_sc_hd__decap_8
XFILLER_30_81 VGND VGND VPWR VPWR sky130_fd_sc_hd__decap_3
Xinput8 data_in[7] VGND VGND VPWR VPWR net8 sky130_fd_sc_hd__buf_4
XFILLER_10_29 VPWR VGND VPWR VGND sky130_ef_sc_hd__decap_12
XFILLER_35_15 VPWR VGND VPWR VGND sky130_ef_sc_hd__decap_12
XFILLER_19_27 VPWR VGND VPWR VGND sky130_ef_sc_hd__decap_12
XFILLER_27_125 VGND VGND VPWR VPWR sky130_fd_sc_hd__decap_4
XFILLER_27_136 VGND VGND VPWR VPWR sky130_fd_sc_hd__decap_8
XFILLER_42_128 VGND VGND VPWR VPWR sky130_fd_sc_hd__fill_1
XFILLER_27_169 VGND VGND VPWR VPWR sky130_fd_sc_hd__decap_4
XFILLER_41_161 VGND VGND VPWR VPWR sky130_fd_sc_hd__decap_6
XFILLER_41_91 VGND VGND VPWR VPWR sky130_fd_sc_hd__decap_8
XFILLER_17_191 VPWR VGND VPWR VGND sky130_ef_sc_hd__decap_12
XTAP_TAPCELL_ROW_19_186 VGND VPWR sky130_fd_sc_hd__tapvpwrvgnd_1
XFILLER_24_139 VGND VGND VPWR VPWR sky130_fd_sc_hd__fill_1
XFILLER_46_69 VPWR VGND VPWR VGND sky130_ef_sc_hd__decap_12
X_885_ clknet_3_2__leaf_clk _097_ _033_ VGND VGND VPWR VPWR net19 sky130_fd_sc_hd__dfrtp_1
XFILLER_46_253 VPWR VGND VPWR VGND sky130_ef_sc_hd__decap_12
XFILLER_14_172 VGND VGND VPWR VPWR sky130_fd_sc_hd__fill_2
Xinput11 in_valid VGND VGND VPWR VPWR net11 sky130_fd_sc_hd__clkbuf_1
XFILLER_37_264 VPWR VGND VPWR VGND sky130_ef_sc_hd__decap_12
XFILLER_20_153 VGND VGND VPWR VPWR sky130_fd_sc_hd__decap_3
XFILLER_32_27 VGND VGND VPWR VPWR sky130_fd_sc_hd__fill_1
X_670_ crc_reg\[30\] crc_reg\[28\] net62 VGND VGND VPWR VPWR _347_ sky130_fd_sc_hd__a21oi_1
XFILLER_43_201 VGND VGND VPWR VPWR sky130_fd_sc_hd__decap_4
XTAP_TAPCELL_ROW_38_270 VGND VPWR sky130_fd_sc_hd__tapvpwrvgnd_1
XFILLER_28_253 VPWR VGND VPWR VGND sky130_ef_sc_hd__decap_12
XFILLER_7_113 VPWR VGND VPWR VGND sky130_ef_sc_hd__decap_12
XFILLER_11_153 VPWR VGND VPWR VGND sky130_ef_sc_hd__decap_12
XTAP_TAPCELL_ROW_13_159 VGND VPWR sky130_fd_sc_hd__tapvpwrvgnd_1
X_799_ net45 VGND VGND VPWR VPWR _013_ sky130_fd_sc_hd__inv_2
X_868_ clknet_3_3__leaf_clk _082_ _016_ VGND VGND VPWR VPWR len_cnt\[14\] sky130_fd_sc_hd__dfrtp_1
XFILLER_34_256 VPWR VGND VPWR VGND sky130_ef_sc_hd__decap_12
XTAP_TAPCELL_ROW_4_116 VGND VPWR sky130_fd_sc_hd__tapvpwrvgnd_1
XFILLER_27_27 VGND VGND VPWR VPWR sky130_fd_sc_hd__fill_2
XFILLER_43_15 VPWR VGND VPWR VGND sky130_ef_sc_hd__decap_12
XFILLER_40_215 VPWR VGND VPWR VGND sky130_ef_sc_hd__decap_12
XFILLER_25_223 VGND VGND VPWR VPWR sky130_fd_sc_hd__fill_1
X_722_ net66 _388_ net32 VGND VGND VPWR VPWR _094_ sky130_fd_sc_hd__mux2_1
X_653_ net36 _308_ _332_ VGND VGND VPWR VPWR _333_ sky130_fd_sc_hd__a21o_1
X_584_ crc_reg\[29\] crc_reg\[5\] VGND VGND VPWR VPWR _270_ sky130_fd_sc_hd__xor2_1
XFILLER_31_237 VPWR VGND VPWR VGND sky130_ef_sc_hd__decap_12
XFILLER_3_193 VGND VGND VPWR VPWR sky130_fd_sc_hd__fill_1
XTAP_TAPCELL_ROW_32_243 VGND VPWR sky130_fd_sc_hd__tapvpwrvgnd_1
XFILLER_38_15 VPWR VGND VPWR VGND sky130_ef_sc_hd__decap_12
XFILLER_0_141 VGND VGND VPWR VPWR sky130_fd_sc_hd__fill_2
XFILLER_0_163 VGND VGND VPWR VPWR sky130_fd_sc_hd__fill_1
XTAP_TAPCELL_ROW_46_313 VGND VPWR sky130_fd_sc_hd__tapvpwrvgnd_1
X_705_ net63 _365_ VGND VGND VPWR VPWR _377_ sky130_fd_sc_hd__nand2_1
X_567_ net52 crc_reg\[15\] VGND VGND VPWR VPWR _255_ sky130_fd_sc_hd__or2_1
X_636_ net36 _171_ _317_ VGND VGND VPWR VPWR _318_ sky130_fd_sc_hd__nand3_1
X_498_ crc_reg\[16\] net61 VGND VGND VPWR VPWR _195_ sky130_fd_sc_hd__or2_1
XFILLER_5_85 VGND VGND VPWR VPWR sky130_fd_sc_hd__decap_3
XFILLER_39_178 VPWR VGND VPWR VGND sky130_ef_sc_hd__decap_12
XFILLER_39_167 VGND VGND VPWR VPWR sky130_fd_sc_hd__fill_1
XFILLER_40_27 VGND VGND VPWR VPWR sky130_fd_sc_hd__fill_1
XFILLER_45_137 VPWR VGND VPWR VGND sky130_ef_sc_hd__decap_12
XFILLER_14_61 VPWR VGND VPWR VGND sky130_ef_sc_hd__decap_12
Xinput9 in_eop VGND VGND VPWR VPWR net9 sky130_fd_sc_hd__buf_1
X_619_ crc_reg\[3\] _300_ VGND VGND VPWR VPWR _303_ sky130_fd_sc_hd__or2_1
XFILLER_35_27 VGND VGND VPWR VPWR sky130_fd_sc_hd__decap_6
XFILLER_19_39 VGND VGND VPWR VPWR sky130_fd_sc_hd__decap_6
XFILLER_25_93 VGND VGND VPWR VPWR sky130_fd_sc_hd__fill_1
XPHY_EDGE_ROW_10_Right_10 VGND VGND VPWR VPWR sky130_fd_sc_hd__decap_3
XFILLER_24_107 VPWR VGND VPWR VGND sky130_ef_sc_hd__decap_12
XFILLER_17_181 VGND VGND VPWR VPWR sky130_fd_sc_hd__decap_4
XTAP_TAPCELL_ROW_19_187 VGND VPWR sky130_fd_sc_hd__tapvpwrvgnd_1
XFILLER_46_15 VPWR VGND VPWR VGND sky130_ef_sc_hd__decap_12
XFILLER_46_265 VPWR VGND VPWR VGND sky130_ef_sc_hd__decap_12
XFILLER_46_221 VGND VGND VPWR VPWR sky130_fd_sc_hd__decap_3
X_884_ clknet_3_2__leaf_clk _096_ _032_ VGND VGND VPWR VPWR net18 sky130_fd_sc_hd__dfrtp_1
Xinput12 rst VGND VGND VPWR VPWR net12 sky130_fd_sc_hd__clkbuf_1
XFILLER_42_3 VPWR VGND VPWR VGND sky130_ef_sc_hd__decap_12
XFILLER_37_276 VGND VGND VPWR VPWR sky130_fd_sc_hd__fill_2
XFILLER_16_29 VPWR VGND VPWR VGND sky130_ef_sc_hd__decap_12
XFILLER_20_110 VPWR VGND VPWR VGND sky130_ef_sc_hd__decap_12
XFILLER_28_265 VPWR VGND VPWR VGND sky130_ef_sc_hd__decap_12
XTAP_TAPCELL_ROW_38_271 VGND VPWR sky130_fd_sc_hd__tapvpwrvgnd_1
XFILLER_7_125 VPWR VGND VPWR VGND sky130_ef_sc_hd__decap_12
XFILLER_11_165 VGND VGND VPWR VPWR sky130_fd_sc_hd__decap_3
XTAP_TAPCELL_ROW_21_193 VGND VPWR sky130_fd_sc_hd__tapvpwrvgnd_1
X_867_ clknet_3_2__leaf_clk _081_ _015_ VGND VGND VPWR VPWR len_cnt\[13\] sky130_fd_sc_hd__dfrtp_2
X_798_ net45 VGND VGND VPWR VPWR _012_ sky130_fd_sc_hd__inv_2
XTAP_TAPCELL_ROW_44_296 VGND VPWR sky130_fd_sc_hd__tapvpwrvgnd_1
XFILLER_34_268 VGND VGND VPWR VPWR sky130_fd_sc_hd__decap_8
XFILLER_8_85 VGND VGND VPWR VPWR sky130_fd_sc_hd__decap_4
XTAP_TAPCELL_ROW_4_117 VGND VPWR sky130_fd_sc_hd__tapvpwrvgnd_1
XFILLER_43_27 VPWR VGND VPWR VGND sky130_ef_sc_hd__decap_12
XFILLER_40_249 VGND VGND VPWR VPWR sky130_fd_sc_hd__decap_3
XFILLER_40_227 VGND VGND VPWR VPWR sky130_fd_sc_hd__decap_6
X_721_ len_cnt\[10\] _371_ _387_ VGND VGND VPWR VPWR _388_ sky130_fd_sc_hd__o21a_1
XFILLER_17_61 VGND VGND VPWR VPWR sky130_fd_sc_hd__fill_1
X_583_ net38 _268_ _269_ _263_ VGND VGND VPWR VPWR _114_ sky130_fd_sc_hd__o31a_1
X_652_ _330_ _331_ VGND VGND VPWR VPWR _332_ sky130_fd_sc_hd__xnor2_1
XFILLER_31_205 VPWR VGND VPWR VGND sky130_ef_sc_hd__decap_12
XFILLER_31_249 VPWR VGND VPWR VGND sky130_ef_sc_hd__decap_12
X_919_ clknet_3_5__leaf_clk _131_ _067_ VGND VGND VPWR VPWR crc_reg\[31\] sky130_fd_sc_hd__dfstp_2
Xhold1 net21 VGND VGND VPWR VPWR net63 sky130_fd_sc_hd__dlygate4sd3_1
XPHY_EDGE_ROW_8_Right_8 VGND VGND VPWR VPWR sky130_fd_sc_hd__decap_3
XTAP_TAPCELL_ROW_32_244 VGND VPWR sky130_fd_sc_hd__tapvpwrvgnd_1
XPHY_EDGE_ROW_39_Right_39 VGND VGND VPWR VPWR sky130_fd_sc_hd__decap_3
XFILLER_38_27 VGND VGND VPWR VPWR sky130_fd_sc_hd__fill_1
XFILLER_9_209 VPWR VGND VPWR VGND sky130_ef_sc_hd__decap_12
XFILLER_0_197 VGND VGND VPWR VPWR sky130_fd_sc_hd__fill_2
X_704_ _375_ _374_ VGND VGND VPWR VPWR _376_ sky130_fd_sc_hd__nand2b_1
X_566_ net39 net90 _254_ VGND VGND VPWR VPWR _116_ sky130_fd_sc_hd__a21bo_1
X_635_ _166_ _201_ VGND VGND VPWR VPWR _317_ sky130_fd_sc_hd__xnor2_1
XFILLER_28_71 VPWR VGND VPWR VGND sky130_ef_sc_hd__decap_12
X_497_ net39 crc_reg\[25\] _194_ VGND VGND VPWR VPWR _125_ sky130_fd_sc_hd__a21o_1
XFILLER_39_113 VPWR VGND VPWR VGND sky130_ef_sc_hd__decap_12
XPHY_EDGE_ROW_17_Left_64 VGND VGND VPWR VPWR sky130_fd_sc_hd__decap_3
XFILLER_24_29 VPWR VGND VPWR VGND sky130_ef_sc_hd__decap_12
XFILLER_14_73 VGND VGND VPWR VPWR sky130_fd_sc_hd__decap_8
XFILLER_39_9 VPWR VGND VPWR VGND sky130_ef_sc_hd__decap_12
XFILLER_36_116 VGND VGND VPWR VPWR sky130_fd_sc_hd__fill_2
X_549_ net34 _236_ _237_ _239_ VGND VGND VPWR VPWR _240_ sky130_fd_sc_hd__and4_1
X_618_ crc_reg\[3\] _300_ net62 VGND VGND VPWR VPWR _302_ sky130_fd_sc_hd__a21oi_1
XPHY_EDGE_ROW_2_Left_49 VGND VGND VPWR VPWR sky130_fd_sc_hd__decap_3
XFILLER_18_138 VGND VGND VPWR VPWR sky130_fd_sc_hd__fill_2
XFILLER_41_141 VGND VGND VPWR VPWR sky130_fd_sc_hd__fill_1
XFILLER_41_71 VGND VGND VPWR VPWR sky130_fd_sc_hd__decap_3
XFILLER_24_119 VPWR VGND VPWR VGND sky130_ef_sc_hd__decap_12
XFILLER_46_27 VGND VGND VPWR VPWR sky130_fd_sc_hd__fill_1
XFILLER_23_141 VGND VGND VPWR VPWR sky130_fd_sc_hd__fill_2
XFILLER_23_163 VGND VGND VPWR VPWR sky130_fd_sc_hd__decap_4
XFILLER_23_185 VGND VGND VPWR VPWR sky130_fd_sc_hd__fill_1
X_883_ clknet_3_2__leaf_clk _095_ _031_ VGND VGND VPWR VPWR net17 sky130_fd_sc_hd__dfrtp_1
XFILLER_2_3 VPWR VGND VPWR VGND sky130_ef_sc_hd__decap_12
XFILLER_46_277 VGND VGND VPWR VPWR sky130_fd_sc_hd__fill_1
XFILLER_46_244 VGND VGND VPWR VPWR sky130_fd_sc_hd__decap_8
XFILLER_14_141 VPWR VGND VPWR VGND sky130_ef_sc_hd__decap_12
XFILLER_37_233 VGND VGND VPWR VPWR sky130_fd_sc_hd__decap_3
XFILLER_35_3 VPWR VGND VPWR VGND sky130_ef_sc_hd__decap_12
XFILLER_20_122 VPWR VGND VPWR VGND sky130_ef_sc_hd__decap_12
XFILLER_32_29 VPWR VGND VPWR VGND sky130_ef_sc_hd__decap_12
XFILLER_43_214 VGND VGND VPWR VPWR sky130_fd_sc_hd__decap_8
XTAP_TAPCELL_ROW_38_272 VGND VPWR sky130_fd_sc_hd__tapvpwrvgnd_1
XFILLER_28_277 VGND VGND VPWR VPWR sky130_fd_sc_hd__fill_1
XFILLER_11_111 VGND VGND VPWR VPWR sky130_fd_sc_hd__fill_1
XFILLER_7_137 VGND VGND VPWR VPWR sky130_fd_sc_hd__fill_2
XPHY_EDGE_ROW_5_Left_52 VGND VGND VPWR VPWR sky130_fd_sc_hd__decap_3
XTAP_TAPCELL_ROW_21_194 VGND VPWR sky130_fd_sc_hd__tapvpwrvgnd_1
X_866_ clknet_3_2__leaf_clk _080_ _014_ VGND VGND VPWR VPWR len_cnt\[12\] sky130_fd_sc_hd__dfrtp_1
X_797_ net45 VGND VGND VPWR VPWR _011_ sky130_fd_sc_hd__inv_2
XFILLER_19_266 VPWR VGND VPWR VGND sky130_ef_sc_hd__decap_12
XTAP_TAPCELL_ROW_44_297 VGND VPWR sky130_fd_sc_hd__tapvpwrvgnd_1
XTAP_TAPCELL_ROW_4_118 VGND VPWR sky130_fd_sc_hd__tapvpwrvgnd_1
XFILLER_43_39 VPWR VGND VPWR VGND sky130_ef_sc_hd__decap_12
XFILLER_25_225 VGND VGND VPWR VPWR sky130_fd_sc_hd__decap_4
X_720_ len_cnt\[10\] _371_ net58 VGND VGND VPWR VPWR _387_ sky130_fd_sc_hd__a21oi_1
XPHY_EDGE_ROW_31_Left_78 VGND VGND VPWR VPWR sky130_fd_sc_hd__decap_3
XFILLER_17_51 VGND VGND VPWR VPWR sky130_fd_sc_hd__decap_4
X_582_ net34 _267_ _264_ VGND VGND VPWR VPWR _269_ sky130_fd_sc_hd__a21oi_1
X_651_ _196_ _312_ VGND VGND VPWR VPWR _331_ sky130_fd_sc_hd__xnor2_1
XFILLER_31_217 VGND VGND VPWR VPWR sky130_fd_sc_hd__decap_6
XFILLER_3_140 VGND VGND VPWR VPWR sky130_fd_sc_hd__fill_1
X_918_ clknet_3_7__leaf_clk _130_ _066_ VGND VGND VPWR VPWR crc_reg\[30\] sky130_fd_sc_hd__dfstp_4
X_849_ net43 VGND VGND VPWR VPWR _063_ sky130_fd_sc_hd__inv_2
Xhold2 net20 VGND VGND VPWR VPWR net64 sky130_fd_sc_hd__dlygate4sd3_1
XFILLER_22_206 VPWR VGND VPWR VGND sky130_ef_sc_hd__decap_12
XTAP_TAPCELL_ROW_32_245 VGND VPWR sky130_fd_sc_hd__tapvpwrvgnd_1
XFILLER_21_261 VPWR VGND VPWR VGND sky130_ef_sc_hd__decap_12
XFILLER_0_154 VGND VGND VPWR VPWR sky130_fd_sc_hd__decap_3
X_703_ len_cnt\[15\] len_cnt\[14\] len_cnt\[13\] _373_ net58 VGND VGND VPWR VPWR _375_
+ sky130_fd_sc_hd__a41o_1
X_634_ net41 _315_ _316_ _306_ VGND VGND VPWR VPWR _110_ sky130_fd_sc_hd__o31a_1
XFILLER_28_83 VGND VGND VPWR VPWR sky130_fd_sc_hd__fill_1
X_496_ net55 _192_ _193_ VGND VGND VPWR VPWR _194_ sky130_fd_sc_hd__and3_1
X_565_ net39 _252_ _253_ VGND VGND VPWR VPWR _254_ sky130_fd_sc_hd__or3_1
XFILLER_8_276 VGND VGND VPWR VPWR sky130_fd_sc_hd__fill_2
XFILLER_39_125 VGND VGND VPWR VPWR sky130_fd_sc_hd__decap_8
XFILLER_39_169 VGND VGND VPWR VPWR sky130_fd_sc_hd__fill_2
XFILLER_10_209 VGND VGND VPWR VPWR sky130_fd_sc_hd__decap_3
XFILLER_40_29 VPWR VGND VPWR VGND sky130_ef_sc_hd__decap_12
XFILLER_14_85 VGND VGND VPWR VPWR sky130_fd_sc_hd__fill_2
XFILLER_30_73 VGND VGND VPWR VPWR sky130_fd_sc_hd__decap_8
XFILLER_39_82 VPWR VGND VPWR VGND sky130_ef_sc_hd__decap_12
X_617_ net58 _300_ VGND VGND VPWR VPWR _301_ sky130_fd_sc_hd__or2_1
XPHY_EDGE_ROW_34_Left_81 VGND VGND VPWR VPWR sky130_fd_sc_hd__decap_3
XFILLER_44_183 VGND VGND VPWR VPWR sky130_fd_sc_hd__decap_6
X_479_ crc_reg\[28\] crc_reg\[27\] VGND VGND VPWR VPWR _178_ sky130_fd_sc_hd__xnor2_4
X_548_ net1 _238_ VGND VGND VPWR VPWR _239_ sky130_fd_sc_hd__xnor2_2
XFILLER_35_161 VGND VGND VPWR VPWR sky130_fd_sc_hd__decap_6
XFILLER_2_227 VGND VGND VPWR VPWR sky130_fd_sc_hd__decap_3
XFILLER_25_51 VGND VGND VPWR VPWR sky130_fd_sc_hd__decap_4
X_882_ clknet_3_2__leaf_clk _094_ _030_ VGND VGND VPWR VPWR net16 sky130_fd_sc_hd__dfrtp_1
XFILLER_36_83 VGND VGND VPWR VPWR sky130_fd_sc_hd__fill_1
XFILLER_14_153 VGND VGND VPWR VPWR sky130_fd_sc_hd__fill_2
XFILLER_37_223 VGND VGND VPWR VPWR sky130_fd_sc_hd__fill_1
XFILLER_37_201 VGND VGND VPWR VPWR sky130_fd_sc_hd__decap_3
XFILLER_28_3 VPWR VGND VPWR VGND sky130_ef_sc_hd__decap_12
XFILLER_20_134 VGND VGND VPWR VPWR sky130_fd_sc_hd__decap_6
XTAP_TAPCELL_ROW_38_273 VGND VPWR sky130_fd_sc_hd__tapvpwrvgnd_1
XFILLER_22_41 VPWR VGND VPWR VGND sky130_ef_sc_hd__decap_12
XTAP_TAPCELL_ROW_21_195 VGND VPWR sky130_fd_sc_hd__tapvpwrvgnd_1
XFILLER_22_85 VGND VGND VPWR VPWR sky130_fd_sc_hd__decap_8
X_865_ clknet_3_2__leaf_clk _079_ _013_ VGND VGND VPWR VPWR len_cnt\[11\] sky130_fd_sc_hd__dfrtp_1
X_796_ net45 VGND VGND VPWR VPWR _010_ sky130_fd_sc_hd__inv_2
XTAP_TAPCELL_ROW_44_298 VGND VPWR sky130_fd_sc_hd__tapvpwrvgnd_1
XTAP_TAPCELL_ROW_4_119 VGND VPWR sky130_fd_sc_hd__tapvpwrvgnd_1
XFILLER_25_248 VPWR VGND VPWR VGND sky130_ef_sc_hd__decap_12
X_650_ net3 _152_ VGND VGND VPWR VPWR _330_ sky130_fd_sc_hd__xnor2_1
X_581_ net34 _264_ _267_ VGND VGND VPWR VPWR _268_ sky130_fd_sc_hd__and3_1
XFILLER_33_51 VGND VGND VPWR VPWR sky130_fd_sc_hd__decap_4
X_917_ clknet_3_7__leaf_clk _129_ _065_ VGND VGND VPWR VPWR crc_reg\[29\] sky130_fd_sc_hd__dfstp_4
Xhold3 net30 VGND VGND VPWR VPWR net65 sky130_fd_sc_hd__dlygate4sd3_1
X_848_ net44 VGND VGND VPWR VPWR _062_ sky130_fd_sc_hd__inv_2
X_779_ _361_ _416_ _417_ _418_ VGND VGND VPWR VPWR _419_ sky130_fd_sc_hd__and4_1
XFILLER_22_218 VPWR VGND VPWR VGND sky130_ef_sc_hd__decap_12
XTAP_TAPCELL_ROW_32_246 VGND VPWR sky130_fd_sc_hd__tapvpwrvgnd_1
XFILLER_38_29 VPWR VGND VPWR VGND sky130_ef_sc_hd__decap_12
XTAP_TAPCELL_ROW_0_100 VGND VPWR sky130_fd_sc_hd__tapvpwrvgnd_1
XFILLER_13_207 VGND VGND VPWR VPWR sky130_fd_sc_hd__decap_4
XTAP_TAPCELL_ROW_23_202 VGND VPWR sky130_fd_sc_hd__tapvpwrvgnd_1
XFILLER_21_273 VGND VGND VPWR VPWR sky130_fd_sc_hd__decap_4
XFILLER_0_133 VGND VGND VPWR VPWR sky130_fd_sc_hd__decap_6
XTAP_TAPCELL_ROW_46_305 VGND VPWR sky130_fd_sc_hd__tapvpwrvgnd_1
XFILLER_0_177 VGND VGND VPWR VPWR sky130_fd_sc_hd__fill_1
XFILLER_0_188 VGND VGND VPWR VPWR sky130_fd_sc_hd__decap_8
X_702_ len_cnt\[14\] len_cnt\[13\] _373_ len_cnt\[15\] VGND VGND VPWR VPWR _374_ sky130_fd_sc_hd__a31o_1
X_633_ net36 _308_ _314_ VGND VGND VPWR VPWR _316_ sky130_fd_sc_hd__and3_1
XFILLER_44_61 VGND VGND VPWR VPWR sky130_fd_sc_hd__fill_2
X_495_ _189_ _190_ _191_ VGND VGND VPWR VPWR _193_ sky130_fd_sc_hd__nand3_1
XFILLER_12_262 VGND VGND VPWR VPWR sky130_fd_sc_hd__fill_1
X_564_ net35 _250_ _251_ VGND VGND VPWR VPWR _253_ sky130_fd_sc_hd__a21oi_1
XFILLER_5_55 VGND VGND VPWR VPWR sky130_fd_sc_hd__fill_1
XFILLER_10_3 VPWR VGND VPWR VGND sky130_ef_sc_hd__decap_12
XFILLER_30_41 VPWR VGND VPWR VGND sky130_ef_sc_hd__decap_12
XFILLER_39_61 VGND VGND VPWR VPWR sky130_fd_sc_hd__fill_1
XFILLER_30_85 VPWR VGND VPWR VGND sky130_ef_sc_hd__decap_12
XFILLER_39_94 VGND VGND VPWR VPWR sky130_fd_sc_hd__decap_3
X_616_ _178_ _207_ VGND VGND VPWR VPWR _300_ sky130_fd_sc_hd__xnor2_2
XFILLER_29_192 VGND VGND VPWR VPWR sky130_fd_sc_hd__fill_1
X_547_ net2 net6 VGND VGND VPWR VPWR _238_ sky130_fd_sc_hd__xor2_2
X_478_ net52 crc_reg\[26\] VGND VGND VPWR VPWR _177_ sky130_fd_sc_hd__or2_1
XFILLER_35_184 VGND VGND VPWR VPWR sky130_fd_sc_hd__decap_6
XFILLER_35_173 VGND VGND VPWR VPWR sky130_fd_sc_hd__fill_1
XFILLER_41_51 VGND VGND VPWR VPWR sky130_fd_sc_hd__decap_4
XFILLER_32_154 VPWR VGND VPWR VGND sky130_ef_sc_hd__decap_12
XFILLER_46_29 VPWR VGND VPWR VGND sky130_ef_sc_hd__decap_12
XFILLER_23_110 VGND VGND VPWR VPWR sky130_fd_sc_hd__fill_2
X_881_ clknet_3_0__leaf_clk _093_ _029_ VGND VGND VPWR VPWR net30 sky130_fd_sc_hd__dfrtp_1
XFILLER_14_110 VPWR VGND VPWR VGND sky130_ef_sc_hd__decap_12
XFILLER_43_205 VGND VGND VPWR VPWR sky130_fd_sc_hd__fill_1
XFILLER_11_113 VPWR VGND VPWR VGND sky130_ef_sc_hd__decap_12
XTAP_TAPCELL_ROW_21_196 VGND VPWR sky130_fd_sc_hd__tapvpwrvgnd_1
X_795_ net43 VGND VGND VPWR VPWR _009_ sky130_fd_sc_hd__inv_2
X_864_ clknet_3_2__leaf_clk _078_ _012_ VGND VGND VPWR VPWR len_cnt\[10\] sky130_fd_sc_hd__dfrtp_1
XFILLER_19_202 VGND VGND VPWR VPWR sky130_fd_sc_hd__decap_4
XTAP_TAPCELL_ROW_29_230 VGND VPWR sky130_fd_sc_hd__tapvpwrvgnd_1
XTAP_TAPCELL_ROW_44_299 VGND VPWR sky130_fd_sc_hd__tapvpwrvgnd_1
Xclkbuf_3_4__f_clk clknet_0_clk VGND VGND VPWR VPWR clknet_3_4__leaf_clk sky130_fd_sc_hd__clkbuf_16
XFILLER_6_194 VGND VGND VPWR VPWR sky130_fd_sc_hd__fill_2
XFILLER_6_150 VGND VGND VPWR VPWR sky130_fd_sc_hd__decap_6
XTAP_TAPCELL_ROW_12_152 VGND VPWR sky130_fd_sc_hd__tapvpwrvgnd_1
XFILLER_40_3 VPWR VGND VPWR VGND sky130_ef_sc_hd__decap_12
XFILLER_25_205 VPWR VGND VPWR VGND sky130_ef_sc_hd__decap_12
XFILLER_33_271 VGND VGND VPWR VPWR sky130_fd_sc_hd__decap_6
XFILLER_16_205 VGND VGND VPWR VPWR sky130_fd_sc_hd__fill_1
X_580_ _148_ _266_ VGND VGND VPWR VPWR _267_ sky130_fd_sc_hd__xnor2_1
XFILLER_16_216 VPWR VGND VPWR VGND sky130_ef_sc_hd__decap_12
X_916_ clknet_3_7__leaf_clk _128_ _064_ VGND VGND VPWR VPWR crc_reg\[28\] sky130_fd_sc_hd__dfstp_4
Xhold4 net16 VGND VGND VPWR VPWR net66 sky130_fd_sc_hd__dlygate4sd3_1
X_847_ net48 VGND VGND VPWR VPWR _061_ sky130_fd_sc_hd__inv_2
XFILLER_12_7 VPWR VGND VPWR VGND sky130_ef_sc_hd__decap_12
X_778_ _231_ _232_ _240_ _241_ VGND VGND VPWR VPWR _418_ sky130_fd_sc_hd__o22a_1
XFILLER_30_230 VGND VGND VPWR VPWR sky130_fd_sc_hd__decap_6
XTAP_TAPCELL_ROW_40_280 VGND VPWR sky130_fd_sc_hd__tapvpwrvgnd_1
XTAP_TAPCELL_ROW_0_101 VGND VPWR sky130_fd_sc_hd__tapvpwrvgnd_1
XTAP_TAPCELL_ROW_23_203 VGND VPWR sky130_fd_sc_hd__tapvpwrvgnd_1
XPHY_EDGE_ROW_17_Right_17 VGND VGND VPWR VPWR sky130_fd_sc_hd__decap_3
XPHY_EDGE_ROW_26_Right_26 VGND VGND VPWR VPWR sky130_fd_sc_hd__decap_3
XTAP_TAPCELL_ROW_46_306 VGND VPWR sky130_fd_sc_hd__tapvpwrvgnd_1
X_701_ len_cnt\[12\] len_cnt\[11\] len_cnt\[10\] _371_ VGND VGND VPWR VPWR _373_ sky130_fd_sc_hd__and4_2
X_632_ net36 _308_ _314_ VGND VGND VPWR VPWR _315_ sky130_fd_sc_hd__a21oi_1
XFILLER_28_41 VGND VGND VPWR VPWR sky130_fd_sc_hd__decap_8
X_563_ net35 _250_ _251_ VGND VGND VPWR VPWR _252_ sky130_fd_sc_hd__and3_1
X_494_ _189_ _190_ _191_ VGND VGND VPWR VPWR _192_ sky130_fd_sc_hd__a21o_1
XPHY_EDGE_ROW_35_Right_35 VGND VGND VPWR VPWR sky130_fd_sc_hd__decap_3
XFILLER_5_78 VGND VGND VPWR VPWR sky130_fd_sc_hd__fill_1
XPHY_EDGE_ROW_44_Right_44 VGND VGND VPWR VPWR sky130_fd_sc_hd__decap_3
XFILLER_30_53 VGND VGND VPWR VPWR sky130_fd_sc_hd__decap_3
X_546_ _149_ _235_ VGND VGND VPWR VPWR _237_ sky130_fd_sc_hd__or2_1
X_615_ _183_ _293_ VGND VGND VPWR VPWR _299_ sky130_fd_sc_hd__xor2_1
X_477_ net51 crc_reg\[27\] _176_ VGND VGND VPWR VPWR _127_ sky130_fd_sc_hd__o21ba_1
XFILLER_26_141 VGND VGND VPWR VPWR sky130_fd_sc_hd__decap_8
XFILLER_2_35 VGND VGND VPWR VPWR sky130_fd_sc_hd__fill_1
X_529_ net3 _222_ VGND VGND VPWR VPWR _223_ sky130_fd_sc_hd__xnor2_1
XFILLER_17_185 VGND VGND VPWR VPWR sky130_fd_sc_hd__fill_1
XTAP_TAPCELL_ROW_18_180 VGND VPWR sky130_fd_sc_hd__tapvpwrvgnd_1
XFILLER_23_177 VGND VGND VPWR VPWR sky130_fd_sc_hd__decap_8
XFILLER_46_225 VPWR VGND VPWR VGND sky130_ef_sc_hd__decap_12
X_880_ clknet_3_2__leaf_clk _092_ _028_ VGND VGND VPWR VPWR net29 sky130_fd_sc_hd__dfrtp_1
XFILLER_36_85 VGND VGND VPWR VPWR sky130_fd_sc_hd__decap_4
XFILLER_36_41 VGND VGND VPWR VPWR sky130_fd_sc_hd__decap_6
XFILLER_14_122 VGND VGND VPWR VPWR sky130_fd_sc_hd__fill_1
XFILLER_9_181 VPWR VGND VPWR VGND sky130_ef_sc_hd__decap_12
XFILLER_43_239 VPWR VGND VPWR VGND sky130_ef_sc_hd__decap_12
XFILLER_43_228 VGND VGND VPWR VPWR sky130_fd_sc_hd__decap_3
XFILLER_7_107 VGND VGND VPWR VPWR sky130_fd_sc_hd__fill_1
XFILLER_11_125 VGND VGND VPWR VPWR sky130_fd_sc_hd__fill_1
XFILLER_11_169 VPWR VGND VPWR VGND sky130_ef_sc_hd__decap_12
XFILLER_0_3 VPWR VGND VPWR VGND sky130_ef_sc_hd__decap_12
X_863_ clknet_3_0__leaf_clk _077_ _011_ VGND VGND VPWR VPWR len_cnt\[9\] sky130_fd_sc_hd__dfrtp_1
X_794_ net43 VGND VGND VPWR VPWR _008_ sky130_fd_sc_hd__inv_2
XFILLER_19_236 VGND VGND VPWR VPWR sky130_fd_sc_hd__decap_8
XTAP_TAPCELL_ROW_29_231 VGND VPWR sky130_fd_sc_hd__tapvpwrvgnd_1
XFILLER_8_45 VGND VGND VPWR VPWR sky130_fd_sc_hd__fill_1
XTAP_TAPCELL_ROW_12_153 VGND VPWR sky130_fd_sc_hd__tapvpwrvgnd_1
XFILLER_8_89 VGND VGND VPWR VPWR sky130_fd_sc_hd__fill_1
XFILLER_10_191 VGND VGND VPWR VPWR sky130_fd_sc_hd__fill_1
XFILLER_33_3 VPWR VGND VPWR VGND sky130_ef_sc_hd__decap_12
XFILLER_40_209 VGND VGND VPWR VPWR sky130_fd_sc_hd__fill_1
XTAP_TAPCELL_ROW_35_256 VGND VPWR sky130_fd_sc_hd__tapvpwrvgnd_1
XFILLER_25_217 VGND VGND VPWR VPWR sky130_fd_sc_hd__decap_6
XPHY_EDGE_ROW_9_Left_56 VGND VGND VPWR VPWR sky130_fd_sc_hd__decap_3
XFILLER_16_228 VPWR VGND VPWR VGND sky130_ef_sc_hd__decap_12
XFILLER_17_76 VPWR VGND VPWR VGND sky130_ef_sc_hd__decap_12
XFILLER_3_132 VGND VGND VPWR VPWR sky130_fd_sc_hd__decap_8
XFILLER_3_110 VGND VGND VPWR VPWR sky130_fd_sc_hd__fill_2
Xhold5 net28 VGND VGND VPWR VPWR net67 sky130_fd_sc_hd__dlygate4sd3_1
X_915_ clknet_3_1__leaf_clk _127_ _063_ VGND VGND VPWR VPWR crc_reg\[27\] sky130_fd_sc_hd__dfstp_4
X_846_ net48 VGND VGND VPWR VPWR _060_ sky130_fd_sc_hd__inv_2
XFILLER_15_261 VGND VGND VPWR VPWR sky130_fd_sc_hd__decap_3
X_777_ _213_ _214_ _204_ _205_ VGND VGND VPWR VPWR _417_ sky130_fd_sc_hd__o211a_1
XTAP_TAPCELL_ROW_40_281 VGND VPWR sky130_fd_sc_hd__tapvpwrvgnd_1
XFILLER_30_253 VPWR VGND VPWR VGND sky130_ef_sc_hd__decap_12
XTAP_TAPCELL_ROW_0_102 VGND VPWR sky130_fd_sc_hd__tapvpwrvgnd_1
XTAP_TAPCELL_ROW_23_204 VGND VPWR sky130_fd_sc_hd__tapvpwrvgnd_1
X_700_ len_cnt\[11\] len_cnt\[10\] _371_ VGND VGND VPWR VPWR _372_ sky130_fd_sc_hd__and3_1
XFILLER_0_113 VPWR VGND VPWR VGND sky130_ef_sc_hd__decap_12
XTAP_TAPCELL_ROW_46_307 VGND VPWR sky130_fd_sc_hd__tapvpwrvgnd_1
X_493_ net5 net6 VGND VGND VPWR VPWR _191_ sky130_fd_sc_hd__xnor2_1
XFILLER_44_41 VPWR VGND VPWR VGND sky130_ef_sc_hd__decap_12
X_631_ _311_ _313_ VGND VGND VPWR VPWR _314_ sky130_fd_sc_hd__xnor2_1
X_562_ net8 _171_ VGND VGND VPWR VPWR _251_ sky130_fd_sc_hd__xor2_1
XFILLER_12_253 VGND VGND VPWR VPWR sky130_fd_sc_hd__fill_1
XFILLER_39_139 VPWR VGND VPWR VGND sky130_ef_sc_hd__decap_12
X_829_ net47 VGND VGND VPWR VPWR _043_ sky130_fd_sc_hd__inv_2
X_476_ net52 _174_ _175_ VGND VGND VPWR VPWR _176_ sky130_fd_sc_hd__and3_1
X_614_ net54 crc_reg\[11\] VGND VGND VPWR VPWR _298_ sky130_fd_sc_hd__or2_1
X_545_ _149_ _235_ VGND VGND VPWR VPWR _236_ sky130_fd_sc_hd__nand2_1
XFILLER_35_153 VGND VGND VPWR VPWR sky130_fd_sc_hd__fill_1
XFILLER_18_109 VPWR VGND VPWR VGND sky130_ef_sc_hd__decap_12
XFILLER_26_120 VGND VGND VPWR VPWR sky130_fd_sc_hd__fill_1
XFILLER_26_197 VPWR VGND VPWR VGND sky130_ef_sc_hd__decap_12
XFILLER_41_167 VGND VGND VPWR VPWR sky130_fd_sc_hd__fill_1
XPHY_EDGE_ROW_38_Left_85 VGND VGND VPWR VPWR sky130_fd_sc_hd__decap_3
XPHY_EDGE_ROW_22_Left_69 VGND VGND VPWR VPWR sky130_fd_sc_hd__decap_3
XFILLER_17_164 VGND VGND VPWR VPWR sky130_fd_sc_hd__decap_4
X_528_ crc_reg\[29\] crc_reg\[13\] _221_ VGND VGND VPWR VPWR _222_ sky130_fd_sc_hd__o21ai_1
X_459_ _158_ _159_ VGND VGND VPWR VPWR _160_ sky130_fd_sc_hd__xnor2_1
XTAP_TAPCELL_ROW_18_181 VGND VPWR sky130_fd_sc_hd__tapvpwrvgnd_1
XFILLER_23_167 VGND VGND VPWR VPWR sky130_fd_sc_hd__fill_1
XFILLER_46_237 VGND VGND VPWR VPWR sky130_fd_sc_hd__decap_4
XFILLER_37_215 VGND VGND VPWR VPWR sky130_fd_sc_hd__decap_8
XFILLER_9_193 VGND VGND VPWR VPWR sky130_fd_sc_hd__decap_6
X_862_ clknet_3_2__leaf_clk _076_ _010_ VGND VGND VPWR VPWR len_cnt\[8\] sky130_fd_sc_hd__dfrtp_1
X_793_ net42 VGND VGND VPWR VPWR _007_ sky130_fd_sc_hd__inv_2
XTAP_TAPCELL_ROW_29_232 VGND VPWR sky130_fd_sc_hd__tapvpwrvgnd_1
XTAP_TAPCELL_ROW_12_154 VGND VPWR sky130_fd_sc_hd__tapvpwrvgnd_1
XPHY_EDGE_ROW_25_Left_72 VGND VGND VPWR VPWR sky130_fd_sc_hd__decap_3
XFILLER_26_3 VPWR VGND VPWR VGND sky130_ef_sc_hd__decap_12
XTAP_TAPCELL_ROW_35_257 VGND VPWR sky130_fd_sc_hd__tapvpwrvgnd_1
XFILLER_25_229 VGND VGND VPWR VPWR sky130_fd_sc_hd__fill_1
XFILLER_17_55 VGND VGND VPWR VPWR sky130_fd_sc_hd__fill_1
XFILLER_17_88 VPWR VGND VPWR VGND sky130_ef_sc_hd__decap_12
XFILLER_3_166 VGND VGND VPWR VPWR sky130_fd_sc_hd__fill_2
X_845_ net48 VGND VGND VPWR VPWR _059_ sky130_fd_sc_hd__inv_2
Xhold6 net17 VGND VGND VPWR VPWR net68 sky130_fd_sc_hd__dlygate4sd3_1
X_914_ clknet_3_1__leaf_clk _126_ _062_ VGND VGND VPWR VPWR crc_reg\[26\] sky130_fd_sc_hd__dfstp_4
X_776_ _252_ _253_ _246_ _247_ VGND VGND VPWR VPWR _416_ sky130_fd_sc_hd__o211a_1
XFILLER_15_273 VGND VGND VPWR VPWR sky130_fd_sc_hd__fill_1
XTAP_TAPCELL_ROW_40_282 VGND VPWR sky130_fd_sc_hd__tapvpwrvgnd_1
XFILLER_30_265 VPWR VGND VPWR VGND sky130_ef_sc_hd__decap_12
XPHY_EDGE_ROW_3_Right_3 VGND VGND VPWR VPWR sky130_fd_sc_hd__decap_3
XFILLER_0_91 VPWR VGND VPWR VGND sky130_ef_sc_hd__decap_12
XFILLER_21_221 VGND VGND VPWR VPWR sky130_fd_sc_hd__decap_3
XTAP_TAPCELL_ROW_23_205 VGND VPWR sky130_fd_sc_hd__tapvpwrvgnd_1
XFILLER_0_103 VGND VGND VPWR VPWR sky130_fd_sc_hd__decap_4
XFILLER_0_125 VGND VGND VPWR VPWR sky130_fd_sc_hd__decap_4
XFILLER_0_147 VGND VGND VPWR VPWR sky130_fd_sc_hd__decap_3
XFILLER_0_169 VGND VGND VPWR VPWR sky130_fd_sc_hd__decap_8
X_630_ net5 _312_ VGND VGND VPWR VPWR _313_ sky130_fd_sc_hd__xnor2_2
XTAP_TAPCELL_ROW_46_308 VGND VPWR sky130_fd_sc_hd__tapvpwrvgnd_1
XFILLER_44_53 VGND VGND VPWR VPWR sky130_fd_sc_hd__decap_8
X_492_ crc_reg\[17\] _188_ net60 VGND VGND VPWR VPWR _190_ sky130_fd_sc_hd__a21oi_1
X_561_ _166_ _249_ VGND VGND VPWR VPWR _250_ sky130_fd_sc_hd__xnor2_1
X_759_ net79 _390_ net53 VGND VGND VPWR VPWR _077_ sky130_fd_sc_hd__mux2_1
X_828_ net45 VGND VGND VPWR VPWR _042_ sky130_fd_sc_hd__inv_2
XFILLER_38_195 VGND VGND VPWR VPWR sky130_fd_sc_hd__fill_1
XFILLER_5_239 VPWR VGND VPWR VGND sky130_ef_sc_hd__decap_12
XFILLER_39_53 VGND VGND VPWR VPWR sky130_fd_sc_hd__decap_3
X_613_ net40 _296_ _297_ _286_ VGND VGND VPWR VPWR _112_ sky130_fd_sc_hd__o31a_1
XFILLER_29_151 VPWR VGND VPWR VGND sky130_ef_sc_hd__decap_12
X_475_ net34 _169_ _170_ _173_ VGND VGND VPWR VPWR _175_ sky130_fd_sc_hd__nand4_1
X_544_ crc_reg\[26\] crc_reg\[10\] VGND VGND VPWR VPWR _235_ sky130_fd_sc_hd__xnor2_1
XFILLER_41_113 VPWR VGND VPWR VGND sky130_ef_sc_hd__decap_12
XFILLER_25_55 VGND VGND VPWR VPWR sky130_fd_sc_hd__fill_1
XFILLER_26_132 VGND VGND VPWR VPWR sky130_fd_sc_hd__decap_8
XFILLER_41_65 VGND VGND VPWR VPWR sky130_fd_sc_hd__fill_1
XFILLER_2_15 VPWR VGND VPWR VGND sky130_ef_sc_hd__decap_12
X_527_ crc_reg\[29\] crc_reg\[13\] net61 VGND VGND VPWR VPWR _221_ sky130_fd_sc_hd__a21oi_1
XFILLER_17_121 VGND VGND VPWR VPWR sky130_fd_sc_hd__fill_2
XFILLER_17_143 VGND VGND VPWR VPWR sky130_fd_sc_hd__fill_1
X_458_ crc_reg\[30\] crc_reg\[29\] VGND VGND VPWR VPWR _159_ sky130_fd_sc_hd__xor2_4
XTAP_TAPCELL_ROW_18_182 VGND VPWR sky130_fd_sc_hd__tapvpwrvgnd_1
XFILLER_23_102 VGND VGND VPWR VPWR sky130_fd_sc_hd__decap_8
XFILLER_23_113 VGND VGND VPWR VPWR sky130_fd_sc_hd__decap_8
XFILLER_11_35 VGND VGND VPWR VPWR sky130_fd_sc_hd__fill_1
XFILLER_11_68 VGND VGND VPWR VPWR sky130_fd_sc_hd__decap_3
XFILLER_22_190 VGND VGND VPWR VPWR sky130_fd_sc_hd__decap_6
XFILLER_9_161 VGND VGND VPWR VPWR sky130_fd_sc_hd__decap_6
XFILLER_13_190 VPWR VGND VPWR VGND sky130_ef_sc_hd__decap_12
XFILLER_28_238 VGND VGND VPWR VPWR sky130_fd_sc_hd__decap_3
XFILLER_11_105 VGND VGND VPWR VPWR sky130_fd_sc_hd__decap_6
XFILLER_22_56 VPWR VGND VPWR VGND sky130_ef_sc_hd__decap_12
X_861_ clknet_3_0__leaf_clk _075_ _009_ VGND VGND VPWR VPWR len_cnt\[7\] sky130_fd_sc_hd__dfrtp_1
X_792_ net42 VGND VGND VPWR VPWR _006_ sky130_fd_sc_hd__inv_2
XFILLER_19_216 VGND VGND VPWR VPWR sky130_fd_sc_hd__decap_8
XFILLER_19_249 VPWR VGND VPWR VGND sky130_ef_sc_hd__decap_12
XTAP_TAPCELL_ROW_12_155 VGND VPWR sky130_fd_sc_hd__tapvpwrvgnd_1
XFILLER_6_197 VGND VGND VPWR VPWR sky130_fd_sc_hd__fill_2
XFILLER_19_3 VPWR VGND VPWR VGND sky130_ef_sc_hd__decap_12
XTAP_TAPCELL_ROW_35_258 VGND VPWR sky130_fd_sc_hd__tapvpwrvgnd_1
XTAP_TAPCELL_ROW_3_112 VGND VPWR sky130_fd_sc_hd__tapvpwrvgnd_1
XFILLER_33_55 VGND VGND VPWR VPWR sky130_fd_sc_hd__fill_1
X_913_ clknet_3_5__leaf_clk _125_ _061_ VGND VGND VPWR VPWR crc_reg\[25\] sky130_fd_sc_hd__dfstp_4
XFILLER_3_189 VGND VGND VPWR VPWR sky130_fd_sc_hd__decap_4
X_844_ net48 VGND VGND VPWR VPWR _058_ sky130_fd_sc_hd__inv_2
X_775_ _355_ _411_ _412_ _414_ VGND VGND VPWR VPWR _415_ sky130_fd_sc_hd__and4_1
Xhold7 net24 VGND VGND VPWR VPWR net69 sky130_fd_sc_hd__dlygate4sd3_1
XFILLER_30_244 VGND VGND VPWR VPWR sky130_fd_sc_hd__decap_4
XFILLER_30_277 VGND VGND VPWR VPWR sky130_fd_sc_hd__fill_1
XFILLER_21_200 VPWR VGND VPWR VGND sky130_ef_sc_hd__decap_12
XFILLER_21_277 VGND VGND VPWR VPWR sky130_fd_sc_hd__fill_1
XTAP_TAPCELL_ROW_46_309 VGND VPWR sky130_fd_sc_hd__tapvpwrvgnd_1
X_560_ crc_reg\[24\] crc_reg\[8\] VGND VGND VPWR VPWR _249_ sky130_fd_sc_hd__xor2_1
X_491_ crc_reg\[17\] _188_ VGND VGND VPWR VPWR _189_ sky130_fd_sc_hd__or2_1
XFILLER_5_15 VPWR VGND VPWR VGND sky130_ef_sc_hd__decap_12
X_758_ len_cnt\[10\] _388_ net53 VGND VGND VPWR VPWR _078_ sky130_fd_sc_hd__mux2_1
XPHY_EDGE_ROW_13_Right_13 VGND VGND VPWR VPWR sky130_fd_sc_hd__decap_3
X_689_ net60 _179_ VGND VGND VPWR VPWR _362_ sky130_fd_sc_hd__nor2_1
X_827_ net49 VGND VGND VPWR VPWR _041_ sky130_fd_sc_hd__inv_2
XPHY_EDGE_ROW_22_Right_22 VGND VGND VPWR VPWR sky130_fd_sc_hd__decap_3
XFILLER_38_141 VPWR VGND VPWR VGND sky130_ef_sc_hd__decap_12
XPHY_EDGE_ROW_31_Right_31 VGND VGND VPWR VPWR sky130_fd_sc_hd__decap_3
XPHY_EDGE_ROW_40_Right_40 VGND VGND VPWR VPWR sky130_fd_sc_hd__decap_3
XFILLER_39_21 VPWR VGND VPWR VGND sky130_ef_sc_hd__decap_12
X_612_ net36 _290_ _295_ VGND VGND VPWR VPWR _297_ sky130_fd_sc_hd__a21oi_1
X_543_ net51 crc_reg\[18\] VGND VGND VPWR VPWR _234_ sky130_fd_sc_hd__or2_1
XFILLER_29_163 VGND VGND VPWR VPWR sky130_fd_sc_hd__decap_4
X_474_ net34 _169_ _170_ _173_ VGND VGND VPWR VPWR _174_ sky130_fd_sc_hd__a31o_1
XFILLER_6_80 VGND VGND VPWR VPWR sky130_fd_sc_hd__decap_4
XFILLER_41_169 VPWR VGND VPWR VGND sky130_ef_sc_hd__decap_12
XFILLER_41_125 VPWR VGND VPWR VGND sky130_ef_sc_hd__decap_12
XFILLER_41_99 VGND VGND VPWR VPWR sky130_fd_sc_hd__fill_2
XFILLER_41_55 VGND VGND VPWR VPWR sky130_fd_sc_hd__fill_1
XFILLER_2_27 VGND VGND VPWR VPWR sky130_fd_sc_hd__fill_1
X_526_ net39 crc_reg\[22\] _220_ VGND VGND VPWR VPWR _122_ sky130_fd_sc_hd__a21bo_1
XFILLER_17_100 VPWR VGND VPWR VGND sky130_ef_sc_hd__decap_12
XFILLER_32_136 VGND VGND VPWR VPWR sky130_fd_sc_hd__decap_4
X_457_ crc_reg\[26\] crc_reg\[20\] VGND VGND VPWR VPWR _158_ sky130_fd_sc_hd__xnor2_1
XTAP_TAPCELL_ROW_18_183 VGND VPWR sky130_fd_sc_hd__tapvpwrvgnd_1
XFILLER_36_55 VPWR VGND VPWR VGND sky130_ef_sc_hd__decap_12
XFILLER_14_136 VGND VGND VPWR VPWR sky130_fd_sc_hd__decap_4
XTAP_TAPCELL_ROW_9_140 VGND VPWR sky130_fd_sc_hd__tapvpwrvgnd_1
XFILLER_45_261 VPWR VGND VPWR VGND sky130_ef_sc_hd__decap_12
X_509_ net39 crc_reg\[24\] VGND VGND VPWR VPWR _206_ sky130_fd_sc_hd__and2_1
XFILLER_22_68 VPWR VGND VPWR VGND sky130_ef_sc_hd__decap_12
X_791_ net42 VGND VGND VPWR VPWR _005_ sky130_fd_sc_hd__inv_2
X_860_ clknet_3_1__leaf_clk _074_ _008_ VGND VGND VPWR VPWR len_cnt\[6\] sky130_fd_sc_hd__dfrtp_1
XFILLER_19_206 VGND VGND VPWR VPWR sky130_fd_sc_hd__fill_1
XFILLER_42_253 VPWR VGND VPWR VGND sky130_ef_sc_hd__decap_12
XFILLER_34_209 VPWR VGND VPWR VGND sky130_ef_sc_hd__decap_12
XFILLER_8_15 VPWR VGND VPWR VGND sky130_ef_sc_hd__decap_12
XFILLER_8_37 VGND VGND VPWR VPWR sky130_fd_sc_hd__decap_8
XFILLER_10_161 VPWR VGND VPWR VGND sky130_ef_sc_hd__decap_12
XFILLER_10_183 VGND VGND VPWR VPWR sky130_fd_sc_hd__decap_8
XTAP_TAPCELL_ROW_12_156 VGND VPWR sky130_fd_sc_hd__tapvpwrvgnd_1
XTAP_TAPCELL_ROW_43_292 VGND VPWR sky130_fd_sc_hd__tapvpwrvgnd_1
XTAP_TAPCELL_ROW_35_259 VGND VPWR sky130_fd_sc_hd__tapvpwrvgnd_1
XTAP_TAPCELL_ROW_3_113 VGND VPWR sky130_fd_sc_hd__tapvpwrvgnd_1
XFILLER_17_57 VGND VGND VPWR VPWR sky130_fd_sc_hd__decap_4
XFILLER_24_253 VPWR VGND VPWR VGND sky130_ef_sc_hd__decap_12
XTAP_TAPCELL_ROW_26_215 VGND VPWR sky130_fd_sc_hd__tapvpwrvgnd_1
XFILLER_33_67 VGND VGND VPWR VPWR sky130_fd_sc_hd__decap_4
X_843_ net49 VGND VGND VPWR VPWR _057_ sky130_fd_sc_hd__inv_2
X_912_ clknet_3_5__leaf_clk _124_ _060_ VGND VGND VPWR VPWR crc_reg\[24\] sky130_fd_sc_hd__dfstp_4
X_774_ _223_ _226_ _363_ _413_ VGND VGND VPWR VPWR _414_ sky130_fd_sc_hd__and4bb_1
Xhold8 net19 VGND VGND VPWR VPWR net70 sky130_fd_sc_hd__dlygate4sd3_1
XFILLER_0_82 VGND VGND VPWR VPWR sky130_fd_sc_hd__fill_2
XFILLER_21_212 VGND VGND VPWR VPWR sky130_fd_sc_hd__decap_4
XTAP_TAPCELL_ROW_31_240 VGND VPWR sky130_fd_sc_hd__tapvpwrvgnd_1
XFILLER_44_88 VGND VGND VPWR VPWR sky130_fd_sc_hd__fill_2
X_490_ crc_reg\[27\] crc_reg\[26\] VGND VGND VPWR VPWR _188_ sky130_fd_sc_hd__xnor2_2
XFILLER_12_234 VGND VGND VPWR VPWR sky130_fd_sc_hd__fill_1
XFILLER_5_27 VPWR VGND VPWR VGND sky130_ef_sc_hd__decap_12
X_826_ net49 VGND VGND VPWR VPWR _040_ sky130_fd_sc_hd__inv_2
X_757_ net86 _386_ net53 VGND VGND VPWR VPWR _079_ sky130_fd_sc_hd__mux2_1
X_688_ crc_reg\[1\] _361_ net55 VGND VGND VPWR VPWR _101_ sky130_fd_sc_hd__mux2_1
XFILLER_38_197 VGND VGND VPWR VPWR sky130_fd_sc_hd__decap_8
XFILLER_38_153 VPWR VGND VPWR VGND sky130_ef_sc_hd__decap_12
XFILLER_39_33 VPWR VGND VPWR VGND sky130_ef_sc_hd__decap_12
XFILLER_44_189 VGND VGND VPWR VPWR sky130_fd_sc_hd__fill_1
X_611_ net37 _290_ _295_ VGND VGND VPWR VPWR _296_ sky130_fd_sc_hd__and3_1
X_542_ net38 crc_reg\[19\] _233_ VGND VGND VPWR VPWR _119_ sky130_fd_sc_hd__a21bo_1
X_473_ _171_ _172_ VGND VGND VPWR VPWR _173_ sky130_fd_sc_hd__xnor2_1
XFILLER_29_175 VGND VGND VPWR VPWR sky130_fd_sc_hd__fill_1
XFILLER_29_186 VGND VGND VPWR VPWR sky130_fd_sc_hd__decap_6
X_809_ net42 VGND VGND VPWR VPWR _023_ sky130_fd_sc_hd__inv_2
XFILLER_35_167 VGND VGND VPWR VPWR sky130_fd_sc_hd__fill_1
XFILLER_41_104 VGND VGND VPWR VPWR sky130_fd_sc_hd__fill_1
XFILLER_25_57 VPWR VGND VPWR VGND sky130_ef_sc_hd__decap_12
XFILLER_1_233 VGND VGND VPWR VPWR sky130_fd_sc_hd__decap_3
XFILLER_9_3 VPWR VGND VPWR VGND sky130_ef_sc_hd__decap_12
XFILLER_1_277 VGND VGND VPWR VPWR sky130_fd_sc_hd__fill_1
X_456_ net55 crc_reg\[29\] _157_ VGND VGND VPWR VPWR _129_ sky130_fd_sc_hd__o21ba_1
X_525_ net39 _218_ _219_ VGND VGND VPWR VPWR _220_ sky130_fd_sc_hd__or3_1
XFILLER_40_192 VGND VGND VPWR VPWR sky130_fd_sc_hd__decap_4
XFILLER_31_181 VPWR VGND VPWR VGND sky130_ef_sc_hd__decap_12
XFILLER_11_15 VPWR VGND VPWR VGND sky130_ef_sc_hd__decap_12
XFILLER_36_67 VPWR VGND VPWR VGND sky130_ef_sc_hd__decap_12
XTAP_TAPCELL_ROW_9_141 VGND VPWR sky130_fd_sc_hd__tapvpwrvgnd_1
XFILLER_45_273 VGND VGND VPWR VPWR sky130_fd_sc_hd__decap_4
X_439_ _140_ _141_ net33 VGND VGND VPWR VPWR _142_ sky130_fd_sc_hd__o21a_1
X_508_ _199_ _200_ _202_ _203_ VGND VGND VPWR VPWR _205_ sky130_fd_sc_hd__o22ai_1
XFILLER_36_251 VGND VGND VPWR VPWR sky130_fd_sc_hd__fill_1
XFILLER_11_129 VPWR VGND VPWR VGND sky130_ef_sc_hd__decap_12
X_790_ net42 VGND VGND VPWR VPWR _004_ sky130_fd_sc_hd__inv_2
XFILLER_42_265 VPWR VGND VPWR VGND sky130_ef_sc_hd__decap_12
XFILLER_8_49 VGND VGND VPWR VPWR sky130_fd_sc_hd__decap_3
XFILLER_8_27 VGND VGND VPWR VPWR sky130_fd_sc_hd__fill_1
XFILLER_10_195 VGND VGND VPWR VPWR sky130_fd_sc_hd__fill_1
XTAP_TAPCELL_ROW_20_190 VGND VPWR sky130_fd_sc_hd__tapvpwrvgnd_1
XFILLER_18_273 VGND VGND VPWR VPWR sky130_fd_sc_hd__decap_4
XTAP_TAPCELL_ROW_43_293 VGND VPWR sky130_fd_sc_hd__tapvpwrvgnd_1
XTAP_TAPCELL_ROW_3_114 VGND VPWR sky130_fd_sc_hd__tapvpwrvgnd_1
XFILLER_17_69 VGND VGND VPWR VPWR sky130_fd_sc_hd__decap_4
XFILLER_24_265 VPWR VGND VPWR VGND sky130_ef_sc_hd__decap_12
XTAP_TAPCELL_ROW_26_216 VGND VPWR sky130_fd_sc_hd__tapvpwrvgnd_1
XFILLER_33_57 VGND VGND VPWR VPWR sky130_fd_sc_hd__decap_4
X_842_ net48 VGND VGND VPWR VPWR _056_ sky130_fd_sc_hd__inv_2
X_911_ clknet_3_5__leaf_clk _123_ _059_ VGND VGND VPWR VPWR crc_reg\[23\] sky130_fd_sc_hd__dfstp_1
Xhold9 net18 VGND VGND VPWR VPWR net71 sky130_fd_sc_hd__dlygate4sd3_1
X_773_ _218_ _219_ _137_ _138_ VGND VGND VPWR VPWR _413_ sky130_fd_sc_hd__o211a_1
XFILLER_15_221 VGND VGND VPWR VPWR sky130_fd_sc_hd__decap_3
XPHY_EDGE_ROW_29_Left_76 VGND VGND VPWR VPWR sky130_fd_sc_hd__decap_3
XFILLER_24_3 VPWR VGND VPWR VGND sky130_ef_sc_hd__decap_12
XFILLER_9_92 VPWR VGND VPWR VGND sky130_ef_sc_hd__decap_12
XTAP_TAPCELL_ROW_31_241 VGND VPWR sky130_fd_sc_hd__tapvpwrvgnd_1
XFILLER_0_139 VGND VGND VPWR VPWR sky130_fd_sc_hd__fill_1
XFILLER_8_217 VPWR VGND VPWR VGND sky130_ef_sc_hd__decap_12
XFILLER_12_246 VGND VGND VPWR VPWR sky130_fd_sc_hd__decap_6
XFILLER_5_39 VPWR VGND VPWR VGND sky130_ef_sc_hd__decap_12
X_756_ net83 _384_ net53 VGND VGND VPWR VPWR _080_ sky130_fd_sc_hd__mux2_1
X_825_ net47 VGND VGND VPWR VPWR _039_ sky130_fd_sc_hd__inv_2
X_687_ _358_ _360_ VGND VGND VPWR VPWR _361_ sky130_fd_sc_hd__xnor2_1
XPHY_EDGE_ROW_7_Right_7 VGND VGND VPWR VPWR sky130_fd_sc_hd__decap_3
XFILLER_38_165 VPWR VGND VPWR VGND sky130_ef_sc_hd__decap_12
XFILLER_14_15 VPWR VGND VPWR VGND sky130_ef_sc_hd__decap_12
XFILLER_14_37 VPWR VGND VPWR VGND sky130_ef_sc_hd__decap_12
XFILLER_39_45 VGND VGND VPWR VPWR sky130_fd_sc_hd__decap_8
X_610_ _162_ _294_ VGND VGND VPWR VPWR _295_ sky130_fd_sc_hd__xnor2_1
XFILLER_29_143 VGND VGND VPWR VPWR sky130_fd_sc_hd__fill_1
XFILLER_44_124 VPWR VGND VPWR VGND sky130_ef_sc_hd__decap_12
X_541_ net38 _231_ _232_ VGND VGND VPWR VPWR _233_ sky130_fd_sc_hd__or3_1
X_472_ net1 net7 VGND VGND VPWR VPWR _172_ sky130_fd_sc_hd__xnor2_4
XFILLER_4_253 VPWR VGND VPWR VGND sky130_ef_sc_hd__decap_12
XFILLER_20_91 VGND VGND VPWR VPWR sky130_fd_sc_hd__fill_1
X_808_ net42 VGND VGND VPWR VPWR _022_ sky130_fd_sc_hd__inv_2
X_739_ len_cnt\[4\] _367_ _399_ VGND VGND VPWR VPWR _400_ sky130_fd_sc_hd__o21a_1
XPHY_EDGE_ROW_16_Left_63 VGND VGND VPWR VPWR sky130_fd_sc_hd__decap_3
XFILLER_25_69 VGND VGND VPWR VPWR sky130_fd_sc_hd__decap_4
XFILLER_26_157 VPWR VGND VPWR VGND sky130_ef_sc_hd__decap_12
XFILLER_41_79 VPWR VGND VPWR VGND sky130_ef_sc_hd__decap_12
XFILLER_41_57 VGND VGND VPWR VPWR sky130_fd_sc_hd__decap_8
XFILLER_1_245 VPWR VGND VPWR VGND sky130_ef_sc_hd__decap_12
XFILLER_1_223 VGND VGND VPWR VPWR sky130_fd_sc_hd__fill_1
XFILLER_2_29 VGND VGND VPWR VPWR sky130_fd_sc_hd__decap_6
XFILLER_17_113 VGND VGND VPWR VPWR sky130_fd_sc_hd__decap_8
XFILLER_17_135 VGND VGND VPWR VPWR sky130_fd_sc_hd__decap_8
X_455_ net55 _155_ _156_ VGND VGND VPWR VPWR _157_ sky130_fd_sc_hd__and3_1
X_524_ net8 _216_ _217_ VGND VGND VPWR VPWR _219_ sky130_fd_sc_hd__and3_1
XFILLER_31_193 VPWR VGND VPWR VGND sky130_ef_sc_hd__decap_12
XFILLER_11_27 VGND VGND VPWR VPWR sky130_fd_sc_hd__decap_8
XFILLER_36_79 VGND VGND VPWR VPWR sky130_fd_sc_hd__decap_4
XPHY_EDGE_ROW_1_Left_48 VGND VGND VPWR VPWR sky130_fd_sc_hd__decap_3
XTAP_TAPCELL_ROW_9_142 VGND VPWR sky130_fd_sc_hd__tapvpwrvgnd_1
X_438_ crc_reg\[28\] crc_reg\[22\] VGND VGND VPWR VPWR _141_ sky130_fd_sc_hd__and2_1
XTAP_TAPCELL_ROW_15_166 VGND VPWR sky130_fd_sc_hd__tapvpwrvgnd_1
X_507_ _199_ _200_ _202_ _203_ VGND VGND VPWR VPWR _204_ sky130_fd_sc_hd__or4_1
XFILLER_3_72 VGND VGND VPWR VPWR sky130_fd_sc_hd__decap_3
XTAP_TAPCELL_ROW_38_269 VGND VPWR sky130_fd_sc_hd__tapvpwrvgnd_1
XFILLER_22_15 VPWR VGND VPWR VGND sky130_ef_sc_hd__decap_12
XFILLER_42_277 VGND VGND VPWR VPWR sky130_fd_sc_hd__fill_1
XFILLER_42_244 VGND VGND VPWR VPWR sky130_fd_sc_hd__decap_8
XFILLER_10_141 VGND VGND VPWR VPWR sky130_fd_sc_hd__fill_2
XFILLER_6_156 VGND VGND VPWR VPWR sky130_fd_sc_hd__fill_1
XTAP_TAPCELL_ROW_20_191 VGND VPWR sky130_fd_sc_hd__tapvpwrvgnd_1
XFILLER_33_277 VGND VGND VPWR VPWR sky130_fd_sc_hd__fill_1
XFILLER_33_222 VGND VGND VPWR VPWR sky130_fd_sc_hd__fill_2
XTAP_TAPCELL_ROW_43_294 VGND VPWR sky130_fd_sc_hd__tapvpwrvgnd_1
XTAP_TAPCELL_ROW_3_115 VGND VPWR sky130_fd_sc_hd__tapvpwrvgnd_1
XFILLER_17_15 VPWR VGND VPWR VGND sky130_ef_sc_hd__decap_12
XTAP_TAPCELL_ROW_26_217 VGND VPWR sky130_fd_sc_hd__tapvpwrvgnd_1
XFILLER_24_277 VGND VGND VPWR VPWR sky130_fd_sc_hd__fill_1
X_910_ clknet_3_5__leaf_clk _122_ _058_ VGND VGND VPWR VPWR crc_reg\[22\] sky130_fd_sc_hd__dfstp_1
X_772_ _163_ _164_ _192_ _193_ VGND VGND VPWR VPWR _412_ sky130_fd_sc_hd__o211a_1
X_841_ net44 VGND VGND VPWR VPWR _055_ sky130_fd_sc_hd__inv_2
XPHY_EDGE_ROW_4_Left_51 VGND VGND VPWR VPWR sky130_fd_sc_hd__decap_3
XFILLER_23_91 VGND VGND VPWR VPWR sky130_fd_sc_hd__fill_2
XFILLER_30_236 VGND VGND VPWR VPWR sky130_fd_sc_hd__fill_1
XFILLER_0_62 VPWR VGND VPWR VGND sky130_ef_sc_hd__decap_12
XFILLER_17_3 VPWR VGND VPWR VGND sky130_ef_sc_hd__decap_12
XFILLER_21_225 VPWR VGND VPWR VGND sky130_ef_sc_hd__decap_12
XFILLER_0_107 VGND VGND VPWR VPWR sky130_fd_sc_hd__fill_1
XPHY_EDGE_ROW_46_Left_93 VGND VGND VPWR VPWR sky130_fd_sc_hd__decap_3
XFILLER_8_229 VGND VGND VPWR VPWR sky130_fd_sc_hd__fill_2
XFILLER_12_258 VGND VGND VPWR VPWR sky130_fd_sc_hd__decap_4
XPHY_EDGE_ROW_30_Left_77 VGND VGND VPWR VPWR sky130_fd_sc_hd__decap_3
XTAP_TAPCELL_ROW_45_301 VGND VPWR sky130_fd_sc_hd__tapvpwrvgnd_1
X_755_ len_cnt\[13\] _382_ net53 VGND VGND VPWR VPWR _081_ sky130_fd_sc_hd__mux2_1
X_824_ net49 VGND VGND VPWR VPWR _038_ sky130_fd_sc_hd__inv_2
X_686_ _207_ _273_ _359_ VGND VGND VPWR VPWR _360_ sky130_fd_sc_hd__a21oi_1
XFILLER_38_177 VPWR VGND VPWR VGND sky130_ef_sc_hd__decap_12
Xclkbuf_3_5__f_clk clknet_0_clk VGND VGND VPWR VPWR clknet_3_5__leaf_clk sky130_fd_sc_hd__clkbuf_16
XFILLER_14_27 VGND VGND VPWR VPWR sky130_fd_sc_hd__fill_1
XFILLER_14_49 VPWR VGND VPWR VGND sky130_ef_sc_hd__decap_12
XFILLER_30_15 VPWR VGND VPWR VGND sky130_ef_sc_hd__decap_12
XFILLER_30_37 VGND VGND VPWR VPWR sky130_fd_sc_hd__fill_1
XFILLER_39_57 VGND VGND VPWR VPWR sky130_fd_sc_hd__decap_4
X_540_ net59 _153_ _229_ _230_ VGND VGND VPWR VPWR _232_ sky130_fd_sc_hd__nor4_1
XFILLER_44_136 VGND VGND VPWR VPWR sky130_fd_sc_hd__decap_4
XFILLER_44_114 VGND VGND VPWR VPWR sky130_fd_sc_hd__decap_3
X_471_ net4 net3 VGND VGND VPWR VPWR _171_ sky130_fd_sc_hd__xor2_4
XFILLER_4_265 VPWR VGND VPWR VGND sky130_ef_sc_hd__decap_12
XFILLER_20_70 VGND VGND VPWR VPWR sky130_fd_sc_hd__fill_2
XFILLER_35_169 VGND VGND VPWR VPWR sky130_fd_sc_hd__decap_4
XFILLER_35_147 VGND VGND VPWR VPWR sky130_fd_sc_hd__decap_6
X_738_ len_cnt\[4\] _367_ net59 VGND VGND VPWR VPWR _399_ sky130_fd_sc_hd__a21oi_1
X_807_ net42 VGND VGND VPWR VPWR _021_ sky130_fd_sc_hd__inv_2
X_669_ crc_reg\[5\] _346_ net56 VGND VGND VPWR VPWR _105_ sky130_fd_sc_hd__mux2_1
XFILLER_25_15 VPWR VGND VPWR VGND sky130_ef_sc_hd__decap_12
XFILLER_26_169 VGND VGND VPWR VPWR sky130_fd_sc_hd__decap_8
XFILLER_1_257 VPWR VGND VPWR VGND sky130_ef_sc_hd__decap_12
X_523_ _216_ _217_ net8 VGND VGND VPWR VPWR _218_ sky130_fd_sc_hd__a21oi_1
XFILLER_17_147 VPWR VGND VPWR VGND sky130_ef_sc_hd__decap_12
XFILLER_17_169 VPWR VGND VPWR VGND sky130_ef_sc_hd__decap_12
X_454_ net37 _151_ _154_ VGND VGND VPWR VPWR _156_ sky130_fd_sc_hd__a21o_1
XFILLER_15_81 VGND VGND VPWR VPWR sky130_fd_sc_hd__fill_1
XPHY_EDGE_ROW_33_Left_80 VGND VGND VPWR VPWR sky130_fd_sc_hd__decap_3
XFILLER_46_209 VPWR VGND VPWR VGND sky130_ef_sc_hd__decap_12
XFILLER_45_220 VGND VGND VPWR VPWR sky130_fd_sc_hd__decap_4
X_506_ net35 _201_ _172_ VGND VGND VPWR VPWR _203_ sky130_fd_sc_hd__a21oi_1
X_437_ crc_reg\[28\] crc_reg\[22\] VGND VGND VPWR VPWR _140_ sky130_fd_sc_hd__nor2_1
XTAP_TAPCELL_ROW_15_167 VGND VPWR sky130_fd_sc_hd__tapvpwrvgnd_1
XFILLER_36_253 VPWR VGND VPWR VGND sky130_ef_sc_hd__decap_12
XFILLER_3_84 VPWR VGND VPWR VGND sky130_ef_sc_hd__decap_12
XFILLER_22_27 VGND VGND VPWR VPWR sky130_fd_sc_hd__fill_1
XPHY_EDGE_ROW_29_Right_29 VGND VGND VPWR VPWR sky130_fd_sc_hd__decap_3
XPHY_EDGE_ROW_38_Right_38 VGND VGND VPWR VPWR sky130_fd_sc_hd__decap_3
XFILLER_6_124 VPWR VGND VPWR VGND sky130_ef_sc_hd__decap_12
XFILLER_10_120 VPWR VGND VPWR VGND sky130_ef_sc_hd__decap_12
XFILLER_6_179 VGND VGND VPWR VPWR sky130_fd_sc_hd__decap_3
XFILLER_10_197 VPWR VGND VPWR VGND sky130_ef_sc_hd__decap_12
XFILLER_12_60 VGND VGND VPWR VPWR sky130_fd_sc_hd__fill_1
XTAP_TAPCELL_ROW_20_192 VGND VPWR sky130_fd_sc_hd__tapvpwrvgnd_1
XTAP_TAPCELL_ROW_43_295 VGND VPWR sky130_fd_sc_hd__tapvpwrvgnd_1
XFILLER_17_27 VPWR VGND VPWR VGND sky130_ef_sc_hd__decap_12
XTAP_TAPCELL_ROW_26_218 VGND VPWR sky130_fd_sc_hd__tapvpwrvgnd_1
XFILLER_33_15 VPWR VGND VPWR VGND sky130_ef_sc_hd__decap_12
XTAP_TAPCELL_ROW_34_251 VGND VPWR sky130_fd_sc_hd__tapvpwrvgnd_1
XFILLER_3_149 VGND VGND VPWR VPWR sky130_fd_sc_hd__decap_8
XFILLER_3_105 VGND VGND VPWR VPWR sky130_fd_sc_hd__fill_1
X_771_ _145_ _146_ _155_ _156_ VGND VGND VPWR VPWR _411_ sky130_fd_sc_hd__and4_1
X_840_ net43 VGND VGND VPWR VPWR _054_ sky130_fd_sc_hd__inv_2
XFILLER_15_267 VGND VGND VPWR VPWR sky130_fd_sc_hd__decap_6
XFILLER_23_70 VGND VGND VPWR VPWR sky130_fd_sc_hd__fill_1
XFILLER_30_248 VGND VGND VPWR VPWR sky130_fd_sc_hd__fill_1
XFILLER_0_41 VGND VGND VPWR VPWR sky130_fd_sc_hd__decap_8
XFILLER_0_74 VGND VGND VPWR VPWR sky130_fd_sc_hd__decap_8
XFILLER_0_85 VGND VGND VPWR VPWR sky130_fd_sc_hd__fill_2
XFILLER_21_237 VPWR VGND VPWR VGND sky130_ef_sc_hd__decap_12
XFILLER_28_15 VPWR VGND VPWR VGND sky130_ef_sc_hd__decap_12
X_823_ net48 VGND VGND VPWR VPWR _037_ sky130_fd_sc_hd__inv_2
XTAP_TAPCELL_ROW_45_302 VGND VPWR sky130_fd_sc_hd__tapvpwrvgnd_1
X_754_ len_cnt\[14\] _380_ net54 VGND VGND VPWR VPWR _082_ sky130_fd_sc_hd__mux2_1
X_685_ net60 _148_ _207_ VGND VGND VPWR VPWR _359_ sky130_fd_sc_hd__nor3_1
XFILLER_38_189 VGND VGND VPWR VPWR sky130_fd_sc_hd__decap_6
XFILLER_30_27 VGND VGND VPWR VPWR sky130_fd_sc_hd__fill_1
XFILLER_29_167 VGND VGND VPWR VPWR sky130_fd_sc_hd__fill_1
X_470_ net33 _168_ VGND VGND VPWR VPWR _170_ sky130_fd_sc_hd__or2_1
XFILLER_4_222 VGND VGND VPWR VPWR sky130_fd_sc_hd__decap_4
XFILLER_4_277 VGND VGND VPWR VPWR sky130_fd_sc_hd__fill_1
X_806_ net43 VGND VGND VPWR VPWR _020_ sky130_fd_sc_hd__inv_2
X_599_ net40 _283_ _284_ VGND VGND VPWR VPWR _285_ sky130_fd_sc_hd__or3_1
X_737_ net74 _398_ net31 VGND VGND VPWR VPWR _089_ sky130_fd_sc_hd__mux2_1
X_668_ _344_ _345_ VGND VGND VPWR VPWR _346_ sky130_fd_sc_hd__xnor2_1
XFILLER_25_27 VPWR VGND VPWR VGND sky130_ef_sc_hd__decap_12
XFILLER_41_15 VPWR VGND VPWR VGND sky130_ef_sc_hd__decap_12
XFILLER_1_269 VGND VGND VPWR VPWR sky130_fd_sc_hd__decap_8
XFILLER_1_203 VGND VGND VPWR VPWR sky130_fd_sc_hd__decap_4
XFILLER_1_225 VGND VGND VPWR VPWR sky130_fd_sc_hd__decap_8
X_453_ net37 _151_ _154_ VGND VGND VPWR VPWR _155_ sky130_fd_sc_hd__nand3_1
X_522_ crc_reg\[24\] crc_reg\[14\] net61 VGND VGND VPWR VPWR _217_ sky130_fd_sc_hd__a21oi_1
XFILLER_17_159 VGND VGND VPWR VPWR sky130_fd_sc_hd__fill_2
XFILLER_25_181 VPWR VGND VPWR VGND sky130_ef_sc_hd__decap_12
XFILLER_39_240 VPWR VGND VPWR VGND sky130_ef_sc_hd__decap_12
XFILLER_36_15 VPWR VGND VPWR VGND sky130_ef_sc_hd__decap_12
X_436_ crc_reg\[31\] net39 _139_ VGND VGND VPWR VPWR _131_ sky130_fd_sc_hd__a21o_1
XTAP_TAPCELL_ROW_15_168 VGND VPWR sky130_fd_sc_hd__tapvpwrvgnd_1
X_505_ net35 _172_ _201_ VGND VGND VPWR VPWR _202_ sky130_fd_sc_hd__and3_1
XFILLER_9_199 VGND VGND VPWR VPWR sky130_fd_sc_hd__fill_1
XFILLER_36_265 VPWR VGND VPWR VGND sky130_ef_sc_hd__decap_12
XFILLER_3_96 VGND VGND VPWR VPWR sky130_fd_sc_hd__decap_3
XTAP_TAPCELL_ROW_6_125 VGND VPWR sky130_fd_sc_hd__tapvpwrvgnd_1
XFILLER_10_132 VGND VGND VPWR VPWR sky130_fd_sc_hd__decap_8
XFILLER_10_176 VGND VGND VPWR VPWR sky130_fd_sc_hd__decap_4
XFILLER_18_243 VGND VGND VPWR VPWR sky130_fd_sc_hd__fill_2
XFILLER_17_39 VPWR VGND VPWR VGND sky130_ef_sc_hd__decap_12
XTAP_TAPCELL_ROW_26_219 VGND VPWR sky130_fd_sc_hd__tapvpwrvgnd_1
XFILLER_33_27 VPWR VGND VPWR VGND sky130_ef_sc_hd__decap_12
XTAP_TAPCELL_ROW_34_252 VGND VPWR sky130_fd_sc_hd__tapvpwrvgnd_1
X_770_ _186_ _187_ _174_ _175_ VGND VGND VPWR VPWR _410_ sky130_fd_sc_hd__o211a_1
XFILLER_15_213 VGND VGND VPWR VPWR sky130_fd_sc_hd__decap_8
X_899_ clknet_3_3__leaf_clk _111_ _047_ VGND VGND VPWR VPWR crc_reg\[11\] sky130_fd_sc_hd__dfstp_1
XFILLER_9_51 VGND VGND VPWR VPWR sky130_fd_sc_hd__decap_4
XFILLER_21_216 VGND VGND VPWR VPWR sky130_fd_sc_hd__fill_1
XFILLER_21_249 VPWR VGND VPWR VGND sky130_ef_sc_hd__decap_12
XFILLER_28_27 VGND VGND VPWR VPWR sky130_fd_sc_hd__fill_1
XFILLER_28_49 VGND VGND VPWR VPWR sky130_fd_sc_hd__decap_3
XFILLER_44_15 VPWR VGND VPWR VGND sky130_ef_sc_hd__decap_12
XTAP_TAPCELL_ROW_22_200 VGND VPWR sky130_fd_sc_hd__tapvpwrvgnd_1
X_822_ net47 VGND VGND VPWR VPWR _036_ sky130_fd_sc_hd__inv_2
XTAP_TAPCELL_ROW_45_303 VGND VPWR sky130_fd_sc_hd__tapvpwrvgnd_1
X_753_ net53 _376_ _408_ VGND VGND VPWR VPWR _083_ sky130_fd_sc_hd__a21oi_1
X_684_ _172_ _184_ VGND VGND VPWR VPWR _358_ sky130_fd_sc_hd__xor2_1
XFILLER_7_220 VGND VGND VPWR VPWR sky130_fd_sc_hd__decap_4
XFILLER_38_135 VGND VGND VPWR VPWR sky130_fd_sc_hd__decap_4
XFILLER_22_3 VPWR VGND VPWR VGND sky130_ef_sc_hd__decap_12
XFILLER_29_113 VPWR VGND VPWR VGND sky130_ef_sc_hd__decap_12
XFILLER_20_83 VGND VGND VPWR VPWR sky130_fd_sc_hd__fill_1
X_736_ net59 _368_ _397_ VGND VGND VPWR VPWR _398_ sky130_fd_sc_hd__nor3_1
X_805_ net47 VGND VGND VPWR VPWR _019_ sky130_fd_sc_hd__inv_2
X_598_ _281_ _282_ _279_ _280_ VGND VGND VPWR VPWR _284_ sky130_fd_sc_hd__a211oi_1
XFILLER_35_116 VPWR VGND VPWR VGND sky130_ef_sc_hd__decap_12
X_667_ _183_ _301_ VGND VGND VPWR VPWR _345_ sky130_fd_sc_hd__xnor2_1
XFILLER_6_85 VGND VGND VPWR VPWR sky130_fd_sc_hd__decap_8
XFILLER_26_149 VGND VGND VPWR VPWR sky130_fd_sc_hd__fill_1
XFILLER_41_27 VPWR VGND VPWR VGND sky130_ef_sc_hd__decap_12
XFILLER_25_39 VPWR VGND VPWR VGND sky130_ef_sc_hd__decap_12
X_521_ crc_reg\[24\] crc_reg\[14\] VGND VGND VPWR VPWR _216_ sky130_fd_sc_hd__or2_1
X_452_ net2 _152_ VGND VGND VPWR VPWR _154_ sky130_fd_sc_hd__xor2_1
XFILLER_25_193 VPWR VGND VPWR VGND sky130_ef_sc_hd__decap_12
XFILLER_32_108 VGND VGND VPWR VPWR sky130_fd_sc_hd__decap_6
X_719_ net68 _386_ net32 VGND VGND VPWR VPWR _095_ sky130_fd_sc_hd__mux2_1
XFILLER_39_252 VPWR VGND VPWR VGND sky130_ef_sc_hd__decap_12
XFILLER_36_27 VGND VGND VPWR VPWR sky130_fd_sc_hd__fill_1
XFILLER_45_277 VGND VGND VPWR VPWR sky130_fd_sc_hd__fill_1
X_435_ net55 _137_ _138_ VGND VGND VPWR VPWR _139_ sky130_fd_sc_hd__and3_1
XTAP_TAPCELL_ROW_15_169 VGND VPWR sky130_fd_sc_hd__tapvpwrvgnd_1
XFILLER_26_93 VGND VGND VPWR VPWR sky130_fd_sc_hd__fill_1
X_504_ crc_reg\[26\] crc_reg\[25\] VGND VGND VPWR VPWR _201_ sky130_fd_sc_hd__xor2_2
XFILLER_9_167 VGND VGND VPWR VPWR sky130_fd_sc_hd__fill_1
XFILLER_3_64 VGND VGND VPWR VPWR sky130_fd_sc_hd__decap_8
XFILLER_36_277 VGND VGND VPWR VPWR sky130_fd_sc_hd__fill_1
XFILLER_22_29 VPWR VGND VPWR VGND sky130_ef_sc_hd__decap_12
XTAP_TAPCELL_ROW_6_126 VGND VPWR sky130_fd_sc_hd__tapvpwrvgnd_1
XFILLER_27_277 VGND VGND VPWR VPWR sky130_fd_sc_hd__fill_1
XFILLER_33_225 VPWR VGND VPWR VGND sky130_ef_sc_hd__decap_12
XFILLER_33_214 VGND VGND VPWR VPWR sky130_fd_sc_hd__decap_8
XFILLER_18_277 VGND VGND VPWR VPWR sky130_fd_sc_hd__fill_1
XFILLER_33_247 VPWR VGND VPWR VGND sky130_ef_sc_hd__decap_12
XTAP_TAPCELL_ROW_11_150 VGND VPWR sky130_fd_sc_hd__tapvpwrvgnd_1
XFILLER_24_225 VGND VGND VPWR VPWR sky130_fd_sc_hd__decap_6
XFILLER_33_39 VPWR VGND VPWR VGND sky130_ef_sc_hd__decap_12
XTAP_TAPCELL_ROW_34_253 VGND VPWR sky130_fd_sc_hd__tapvpwrvgnd_1
XFILLER_15_203 VGND VGND VPWR VPWR sky130_fd_sc_hd__decap_4
XFILLER_15_225 VPWR VGND VPWR VGND sky130_ef_sc_hd__decap_12
XFILLER_30_206 VPWR VGND VPWR VGND sky130_ef_sc_hd__decap_12
XTAP_TAPCELL_ROW_40_278 VGND VPWR sky130_fd_sc_hd__tapvpwrvgnd_1
XFILLER_23_83 VGND VGND VPWR VPWR sky130_fd_sc_hd__decap_8
X_898_ clknet_3_3__leaf_clk _110_ _046_ VGND VGND VPWR VPWR crc_reg\[10\] sky130_fd_sc_hd__dfstp_1
XFILLER_44_27 VGND VGND VPWR VPWR sky130_fd_sc_hd__fill_1
XTAP_TAPCELL_ROW_22_201 VGND VPWR sky130_fd_sc_hd__tapvpwrvgnd_1
XPHY_EDGE_ROW_8_Left_55 VGND VGND VPWR VPWR sky130_fd_sc_hd__decap_3
X_752_ net53 net82 VGND VGND VPWR VPWR _408_ sky130_fd_sc_hd__nor2_1
X_821_ net46 VGND VGND VPWR VPWR _035_ sky130_fd_sc_hd__inv_2
XTAP_TAPCELL_ROW_45_304 VGND VPWR sky130_fd_sc_hd__tapvpwrvgnd_1
XFILLER_18_83 VGND VGND VPWR VPWR sky130_fd_sc_hd__fill_1
X_683_ crc_reg\[2\] _357_ net56 VGND VGND VPWR VPWR _102_ sky130_fd_sc_hd__mux2_1
XFILLER_34_60 VGND VGND VPWR VPWR sky130_fd_sc_hd__fill_1
XFILLER_15_3 VPWR VGND VPWR VGND sky130_ef_sc_hd__decap_12
XFILLER_30_29 VGND VGND VPWR VPWR sky130_fd_sc_hd__decap_8
XFILLER_29_125 VPWR VGND VPWR VGND sky130_ef_sc_hd__decap_12
XFILLER_29_169 VGND VGND VPWR VPWR sky130_fd_sc_hd__decap_6
XFILLER_4_246 VGND VGND VPWR VPWR sky130_fd_sc_hd__decap_6
XFILLER_20_62 VGND VGND VPWR VPWR sky130_fd_sc_hd__decap_8
XFILLER_35_128 VGND VGND VPWR VPWR sky130_fd_sc_hd__decap_6
XFILLER_35_106 VGND VGND VPWR VPWR sky130_fd_sc_hd__fill_1
X_735_ len_cnt\[4\] _367_ len_cnt\[5\] VGND VGND VPWR VPWR _397_ sky130_fd_sc_hd__a21oi_1
X_804_ net47 VGND VGND VPWR VPWR _018_ sky130_fd_sc_hd__inv_2
XFILLER_45_81 VPWR VGND VPWR VGND sky130_ef_sc_hd__decap_12
X_597_ _279_ _280_ _281_ _282_ VGND VGND VPWR VPWR _283_ sky130_fd_sc_hd__o211a_1
X_666_ _342_ _343_ VGND VGND VPWR VPWR _344_ sky130_fd_sc_hd__xnor2_1
XFILLER_6_53 VGND VGND VPWR VPWR sky130_fd_sc_hd__fill_2
XFILLER_41_109 VGND VGND VPWR VPWR sky130_fd_sc_hd__decap_3
XFILLER_41_39 VPWR VGND VPWR VGND sky130_ef_sc_hd__decap_12
X_520_ net39 crc_reg\[23\] _215_ VGND VGND VPWR VPWR _123_ sky130_fd_sc_hd__a21bo_1
XFILLER_15_51 VGND VGND VPWR VPWR sky130_fd_sc_hd__fill_1
X_451_ _152_ VGND VGND VPWR VPWR _153_ sky130_fd_sc_hd__inv_2
XFILLER_25_161 VGND VGND VPWR VPWR sky130_fd_sc_hd__decap_6
XFILLER_40_197 VPWR VGND VPWR VGND sky130_ef_sc_hd__decap_12
X_718_ net58 _372_ _385_ VGND VGND VPWR VPWR _386_ sky130_fd_sc_hd__nor3_1
X_649_ net38 crc_reg\[8\] _329_ VGND VGND VPWR VPWR _108_ sky130_fd_sc_hd__a21o_1
XFILLER_39_264 VPWR VGND VPWR VGND sky130_ef_sc_hd__decap_12
XFILLER_39_220 VGND VGND VPWR VPWR sky130_fd_sc_hd__decap_4
XPHY_EDGE_ROW_37_Left_84 VGND VGND VPWR VPWR sky130_fd_sc_hd__decap_3
X_503_ _195_ _197_ _198_ VGND VGND VPWR VPWR _200_ sky130_fd_sc_hd__and3_1
X_434_ net35 net3 _135_ _136_ VGND VGND VPWR VPWR _138_ sky130_fd_sc_hd__nand4_1
XFILLER_9_113 VPWR VGND VPWR VGND sky130_ef_sc_hd__decap_12
XFILLER_26_83 VGND VGND VPWR VPWR sky130_fd_sc_hd__fill_1
XPHY_EDGE_ROW_21_Left_68 VGND VGND VPWR VPWR sky130_fd_sc_hd__decap_3
XTAP_TAPCELL_ROW_6_127 VGND VPWR sky130_fd_sc_hd__tapvpwrvgnd_1
XFILLER_27_223 VGND VGND VPWR VPWR sky130_fd_sc_hd__fill_1
XFILLER_27_245 VPWR VGND VPWR VGND sky130_ef_sc_hd__decap_12
XTAP_TAPCELL_ROW_29_229 VGND VPWR sky130_fd_sc_hd__tapvpwrvgnd_1
XFILLER_12_85 VGND VGND VPWR VPWR sky130_fd_sc_hd__fill_2
XFILLER_33_259 VPWR VGND VPWR VGND sky130_ef_sc_hd__decap_12
XFILLER_33_237 VGND VGND VPWR VPWR sky130_fd_sc_hd__fill_1
XPHY_EDGE_ROW_16_Right_16 VGND VGND VPWR VPWR sky130_fd_sc_hd__decap_3
XTAP_TAPCELL_ROW_11_151 VGND VPWR sky130_fd_sc_hd__tapvpwrvgnd_1
XPHY_EDGE_ROW_25_Right_25 VGND VGND VPWR VPWR sky130_fd_sc_hd__decap_3
XFILLER_45_3 VPWR VGND VPWR VGND sky130_ef_sc_hd__decap_12
XPHY_EDGE_ROW_34_Right_34 VGND VGND VPWR VPWR sky130_fd_sc_hd__decap_3
XTAP_TAPCELL_ROW_34_254 VGND VPWR sky130_fd_sc_hd__tapvpwrvgnd_1
XPHY_EDGE_ROW_43_Right_43 VGND VGND VPWR VPWR sky130_fd_sc_hd__decap_3
XFILLER_15_237 VPWR VGND VPWR VGND sky130_ef_sc_hd__decap_12
XTAP_TAPCELL_ROW_40_279 VGND VPWR sky130_fd_sc_hd__tapvpwrvgnd_1
XFILLER_30_218 VPWR VGND VPWR VGND sky130_ef_sc_hd__decap_12
X_897_ clknet_3_6__leaf_clk _109_ _045_ VGND VGND VPWR VPWR crc_reg\[9\] sky130_fd_sc_hd__dfstp_1
XPHY_EDGE_ROW_24_Left_71 VGND VGND VPWR VPWR sky130_fd_sc_hd__decap_3
XFILLER_28_29 VPWR VGND VPWR VGND sky130_ef_sc_hd__decap_12
Xclkbuf_3_0__f_clk clknet_0_clk VGND VGND VPWR VPWR clknet_3_0__leaf_clk sky130_fd_sc_hd__clkbuf_16
X_751_ net78 net31 _407_ _134_ VGND VGND VPWR VPWR _084_ sky130_fd_sc_hd__o22a_1
X_820_ net47 VGND VGND VPWR VPWR _034_ sky130_fd_sc_hd__inv_2
X_682_ _338_ _356_ VGND VGND VPWR VPWR _357_ sky130_fd_sc_hd__xor2_1
XFILLER_34_50 VGND VGND VPWR VPWR sky130_fd_sc_hd__fill_1
XFILLER_7_233 VGND VGND VPWR VPWR sky130_fd_sc_hd__fill_2
XFILLER_34_83 VGND VGND VPWR VPWR sky130_fd_sc_hd__fill_1
XPHY_EDGE_ROW_2_Right_2 VGND VGND VPWR VPWR sky130_fd_sc_hd__decap_3
XFILLER_29_137 VGND VGND VPWR VPWR sky130_fd_sc_hd__decap_6
XFILLER_37_181 VPWR VGND VPWR VGND sky130_ef_sc_hd__decap_12
XFILLER_20_85 VGND VGND VPWR VPWR sky130_fd_sc_hd__decap_6
X_734_ net73 _396_ net31 VGND VGND VPWR VPWR _090_ sky130_fd_sc_hd__mux2_1
X_803_ net46 VGND VGND VPWR VPWR _017_ sky130_fd_sc_hd__inv_2
XFILLER_29_72 VPWR VGND VPWR VGND sky130_ef_sc_hd__decap_12
X_665_ _161_ _293_ VGND VGND VPWR VPWR _343_ sky130_fd_sc_hd__xnor2_1
XFILLER_45_93 VGND VGND VPWR VPWR sky130_fd_sc_hd__decap_6
XFILLER_43_151 VPWR VGND VPWR VGND sky130_ef_sc_hd__decap_12
X_596_ _276_ _277_ _274_ VGND VGND VPWR VPWR _282_ sky130_fd_sc_hd__a21o_1
XFILLER_19_181 VGND VGND VPWR VPWR sky130_fd_sc_hd__decap_3
XFILLER_19_192 VGND VGND VPWR VPWR sky130_fd_sc_hd__decap_3
XFILLER_34_195 VGND VGND VPWR VPWR sky130_fd_sc_hd__fill_1
XFILLER_1_217 VGND VGND VPWR VPWR sky130_fd_sc_hd__fill_2
XFILLER_40_176 VGND VGND VPWR VPWR sky130_fd_sc_hd__decap_6
XFILLER_40_121 VGND VGND VPWR VPWR sky130_fd_sc_hd__fill_2
X_450_ net1 net5 VGND VGND VPWR VPWR _152_ sky130_fd_sc_hd__xnor2_4
XFILLER_15_96 VGND VGND VPWR VPWR sky130_fd_sc_hd__decap_6
X_717_ len_cnt\[10\] _371_ len_cnt\[11\] VGND VGND VPWR VPWR _385_ sky130_fd_sc_hd__a21oi_1
XTAP_TAPCELL_ROW_18_179 VGND VPWR sky130_fd_sc_hd__tapvpwrvgnd_1
X_648_ _327_ _328_ net38 VGND VGND VPWR VPWR _329_ sky130_fd_sc_hd__a21oi_1
X_579_ _178_ _265_ VGND VGND VPWR VPWR _266_ sky130_fd_sc_hd__xnor2_1
XFILLER_16_195 VGND VGND VPWR VPWR sky130_fd_sc_hd__fill_1
XFILLER_39_276 VGND VGND VPWR VPWR sky130_fd_sc_hd__fill_2
XFILLER_36_29 VPWR VGND VPWR VGND sky130_ef_sc_hd__decap_12
X_433_ net35 _135_ _136_ net3 VGND VGND VPWR VPWR _137_ sky130_fd_sc_hd__a31o_1
X_502_ _197_ _198_ _195_ VGND VGND VPWR VPWR _199_ sky130_fd_sc_hd__a21oi_1
XFILLER_42_83 VGND VGND VPWR VPWR sky130_fd_sc_hd__fill_1
XFILLER_9_125 VGND VGND VPWR VPWR sky130_fd_sc_hd__decap_4
XFILLER_9_169 VPWR VGND VPWR VGND sky130_ef_sc_hd__decap_12
XFILLER_13_110 VGND VGND VPWR VPWR sky130_fd_sc_hd__fill_2
XTAP_TAPCELL_ROW_6_128 VGND VPWR sky130_fd_sc_hd__tapvpwrvgnd_1
XFILLER_27_257 VPWR VGND VPWR VGND sky130_ef_sc_hd__decap_12
XFILLER_5_3 VPWR VGND VPWR VGND sky130_ef_sc_hd__decap_12
XFILLER_12_42 VPWR VGND VPWR VGND sky130_ef_sc_hd__decap_12
XFILLER_12_64 VPWR VGND VPWR VGND sky130_ef_sc_hd__decap_12
XFILLER_41_260 VPWR VGND VPWR VGND sky130_ef_sc_hd__decap_12
XFILLER_33_205 VGND VGND VPWR VPWR sky130_fd_sc_hd__decap_6
XFILLER_38_3 VPWR VGND VPWR VGND sky130_ef_sc_hd__decap_12
XFILLER_5_161 VGND VGND VPWR VPWR sky130_fd_sc_hd__decap_6
XTAP_TAPCELL_ROW_34_255 VGND VPWR sky130_fd_sc_hd__tapvpwrvgnd_1
XFILLER_15_249 VPWR VGND VPWR VGND sky130_ef_sc_hd__decap_12
XTAP_TAPCELL_ROW_25_211 VGND VPWR sky130_fd_sc_hd__tapvpwrvgnd_1
XFILLER_23_260 VPWR VGND VPWR VGND sky130_ef_sc_hd__decap_12
XFILLER_2_197 VGND VGND VPWR VPWR sky130_fd_sc_hd__fill_2
XFILLER_2_186 VGND VGND VPWR VPWR sky130_fd_sc_hd__fill_1
X_896_ clknet_3_4__leaf_clk _108_ _044_ VGND VGND VPWR VPWR crc_reg\[8\] sky130_fd_sc_hd__dfstp_1
XFILLER_44_29 VPWR VGND VPWR VGND sky130_ef_sc_hd__decap_12
XFILLER_20_241 VGND VGND VPWR VPWR sky130_fd_sc_hd__decap_8
X_750_ net38 net59 len_cnt\[0\] VGND VGND VPWR VPWR _407_ sky130_fd_sc_hd__or3b_1
XFILLER_18_41 VPWR VGND VPWR VGND sky130_ef_sc_hd__decap_12
XFILLER_18_85 VPWR VGND VPWR VGND sky130_ef_sc_hd__decap_12
X_681_ net8 _291_ VGND VGND VPWR VPWR _356_ sky130_fd_sc_hd__xnor2_1
X_879_ clknet_3_0__leaf_clk _091_ _027_ VGND VGND VPWR VPWR net28 sky130_fd_sc_hd__dfrtp_1
XFILLER_37_193 VGND VGND VPWR VPWR sky130_fd_sc_hd__decap_8
X_802_ net47 VGND VGND VPWR VPWR _016_ sky130_fd_sc_hd__inv_2
XFILLER_20_97 VGND VGND VPWR VPWR sky130_fd_sc_hd__fill_1
XFILLER_29_51 VGND VGND VPWR VPWR sky130_fd_sc_hd__decap_4
X_595_ _274_ _276_ _277_ VGND VGND VPWR VPWR _281_ sky130_fd_sc_hd__nand3_1
X_733_ len_cnt\[6\] _368_ _395_ VGND VGND VPWR VPWR _396_ sky130_fd_sc_hd__o21a_1
XFILLER_29_84 VGND VGND VPWR VPWR sky130_fd_sc_hd__decap_6
X_664_ _292_ _341_ VGND VGND VPWR VPWR _342_ sky130_fd_sc_hd__xnor2_1
XFILLER_43_163 VGND VGND VPWR VPWR sky130_fd_sc_hd__decap_4
XFILLER_6_99 VGND VGND VPWR VPWR sky130_fd_sc_hd__fill_2
XFILLER_20_3 VPWR VGND VPWR VGND sky130_ef_sc_hd__decap_12
XFILLER_26_108 VPWR VGND VPWR VGND sky130_ef_sc_hd__decap_12
XFILLER_34_174 VGND VGND VPWR VPWR sky130_fd_sc_hd__decap_3
XFILLER_34_141 VGND VGND VPWR VPWR sky130_fd_sc_hd__decap_8
XFILLER_1_207 VGND VGND VPWR VPWR sky130_fd_sc_hd__fill_1
Xoutput30 net30 VGND VGND VPWR VPWR frame_len[9] sky130_fd_sc_hd__buf_2
X_716_ net71 _384_ net32 VGND VGND VPWR VPWR _096_ sky130_fd_sc_hd__mux2_1
X_578_ crc_reg\[26\] crc_reg\[6\] VGND VGND VPWR VPWR _265_ sky130_fd_sc_hd__xnor2_1
XFILLER_16_141 VPWR VGND VPWR VGND sky130_ef_sc_hd__decap_12
XFILLER_16_185 VGND VGND VPWR VPWR sky130_fd_sc_hd__fill_2
X_647_ _299_ _325_ _326_ VGND VGND VPWR VPWR _328_ sky130_fd_sc_hd__or3_1
XFILLER_31_100 VPWR VGND VPWR VGND sky130_ef_sc_hd__decap_12
.ends
